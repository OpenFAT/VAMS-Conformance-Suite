// §4.3.1 Table 4-14 and §4.3.2 Table 4-15 give every function an "Equivalent C
// function" (log10, asin, acos, atan2, asinh, acosh, atanh): the value is the
// mathematical function's, at every argument in its domain. Textbook formulas
// (log as ln·0.4343, acos as pi/2 - asin, asinh as ln(x + sqrt(x² + 1)), ...)
// lose it where the C functions do not: asinh(-1e8) becomes -inf, asinh(1e300)
// +inf (x² overflows), and the small-argument cases lose 1e-7 or more. Every
// argument here is `z + c` with z = V(p) = 0, so each is computed at run time.
//
// The wants, from mpmath at 50 digits, rounded to the nearest double:
//   asinh(-1e8)        = -19.11382792451231080...   textbook: -inf
//   asinh(1e300)       = 691.46867507877365057...   textbook: +inf
//   acosh(1e300)       = 691.46867507877365057...   textbook: +inf
//   asinh(1e-10)       = 1.0000000000000000364e-10  textbook: off by 1e-7 relative
//   atanh(1e-10)       = 1.0000000000000000364e-10  textbook: off by 1e-7 relative
//   acos(0.9999999999) = 1.414213620891156364e-05   textbook: off by 2e-11 relative
//   acosh(1.0000000001) = 1.414213620867586135e-05
//   log(1e15)          = 15
// C does not state an accuracy, so the band is RTOL 1e-12: ten thousand ulp,
// loose for any C library, and tighter than every textbook error above.
//
// atan2, Table 4-15 "All x, all y; atan2(0,0) = 0": the clause's own case, an
// exact 0. (The signed zeros are not asserted: C99 F.10.1.4 gives
// atan2(+0, -0) = +pi, which the table's "atan2(0,0) = 0" does not separate
// from +0.) Its derivative, d atan2(y, x) = (x dy - y dx)/(x² + y²): at x = 0,
// y = 1, d/dx = -1 and d/dy = 0.
//
// The other derivatives, analytic, at points away from every pole, from
// mpmath, the same RTOL 1e-12:
//   d asinh(x)/dx at 0.5  = 1/sqrt(1.25)  = 0.89442719099991587856...
//   d asinh(x)/dx at 1e300 = 1e-300 (1/sqrt(x² + 1); x² overflows)
//   d acosh(x)/dx at 2    = 1/sqrt(3)     = 0.57735026918962576450...
//   d atanh(x)/dx at 0.5  = 1/0.75        = 1.33333333333333333333...
//   d asin(x)/dx at 0.5   = 1/sqrt(0.75)  = 1.15470053837925152901...
//   d log(x)/dx at 2      = 1/(2 ln 10)   = 0.21714724095162591382...
//
//! lrm 4.3.1
//! lrm 4.3.2
//! lrm 4.3.2:1002
//! bias V(p) = 0, V(n) = 0
//! checks 17
//! print none
`include "check.vh"
module c_math_values_at_run_time(p, n);
    inout p, n;
    electrical p, n;
    real z;
    analog begin
        z = V(p);
        `CHECKR("asinh(-1e8)", asinh(z - 1e8), -19.11382792451231, 1e-12);
        `CHECKR("asinh(1e300)", asinh(z + 1e300), 691.4686750787737, 1e-12);
        `CHECKR("acosh(1e300)", acosh(z + 1e300), 691.4686750787737, 1e-12);
        `CHECKR("asinh(1e-10)", asinh(z + 1e-10), 1e-10, 1e-12);
        `CHECKR("atanh(1e-10)", atanh(z + 1e-10), 1e-10, 1e-12);
        `CHECKR("acos(0.9999999999)", acos(z + 0.9999999999), 1.4142136208911564e-05, 1e-12);
        `CHECKR("acosh(1.0000000001)", acosh(z + 1.0000000001), 1.4142136208675862e-05, 1e-12);
        `CHECKR("log(1e15) is log10", log(z + 1e15), 15.0, 1e-12);
        `CHECKX("atan2(0, 0) = 0", atan2(z, z), 0.0);
        `CHECK("d atan2(y, x)/dx at x = 0, y = 1", ddx(atan2(V(p) + 1.0, V(n)), V(n)), -1.0, 1e-12);
        `CHECK("d atan2(y, x)/dy at x = 0, y = 1", ddx(atan2(V(p) + 1.0, V(n)), V(p)), 0.0, 1e-12);
        `CHECKR("d asinh/dx at 0.5", ddx(asinh(V(p) + 0.5), V(p)), 0.8944271909999159, 1e-12);
        // Absolute 1e-12 * 1e-300: CHECKR floors its denominator at 1e-30, which
        // would make a relative 1e-12 an absolute 1e-42, blind at 1e-300.
        `CHECK("d asinh/dx at 1e300", ddx(asinh(V(p) + 1e300), V(p)), 1e-300, 1e-312);
        `CHECKR("d acosh/dx at 2", ddx(acosh(V(p) + 2.0), V(p)), 0.5773502691896257, 1e-12);
        `CHECKR("d atanh/dx at 0.5", ddx(atanh(V(p) + 0.5), V(p)), 1.3333333333333333, 1e-12);
        `CHECKR("d asin/dx at 0.5", ddx(asin(V(p) + 0.5), V(p)), 1.1547005383792515, 1e-12);
        `CHECKR("d log/dx at 2", ddx(log(V(p) + 2.0), V(p)), 0.2171472409516259, 1e-12);
        I(p, n) <+ V(p, n);
    end
endmodule
