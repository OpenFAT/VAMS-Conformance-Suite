// §4.5.11.4 laplace_nd: "H(s) = Σ n_k s^k / Σ d_k s^k", so H(0) = n_0/d_0.
// At a held input the filter's steady output is H(0) times the input, and a
// transient that starts at that steady state (the DC operating point) must
// stay there: every derivative of the input is zero.
//
// The denominator is ∏ (1 + s/ω_i) over ω_i = 1e5, 1e6, ..., 1e10 rad/s,
// multiplied out by hand (the elementary symmetric sums of 1/ω_i):
//   d = 1, 1.11111e-5, 1.12232211e-11, 1.123333211e-18, 1.12232211e-26,
//       1.11111e-35, 1e-45
// and the numerator is 0.625, so H(0) = 0.625. The step is 0.1 ns, so the
// slow pole has ω·dt = 1e-5.
//
// HAND DERIVATION. V(in) = 1 is held from the operating point on, so the
// output is 0.625 at every point. The CHECK's 1e-9 is the steady-state
// tolerance asked of the transient.
//
// WHAT IT CATCHES. §4.5.11: "The Laplace transform filters implement lumped
// linear continuous-time filters", and a continuous LTI filter at its steady
// state does not move. How a tool discretises it is its own; this realisation
// fails: direct form on the bilinear-mapped coefficients makes the discrete fixed
// point Σb/Σa, and with ω·dt = 1e-5 that sum is roundoff: the output drifted
// 5.3e-7 off H(0) in these 200 steps (and 1e-3 in 2000). The state-space
// trapezoidal step keeps A·x + B·u = 0 at a held input, so it stays put.
//
//! lrm 4.5.11
//! bias V(in) = 1
//! bias V(n) = 0
//! checks 201
//! time 0e-10, 1e-10, 2e-10, 3e-10, 4e-10, 5e-10, 6e-10, 7e-10, 8e-10, 9e-10, 10e-10, 11e-10, 12e-10, 13e-10, 14e-10, 15e-10, 16e-10, 17e-10, 18e-10, 19e-10, 20e-10, 21e-10, 22e-10, 23e-10, 24e-10, 25e-10, 26e-10, 27e-10, 28e-10, 29e-10, 30e-10, 31e-10, 32e-10, 33e-10, 34e-10, 35e-10, 36e-10, 37e-10, 38e-10, 39e-10, 40e-10, 41e-10, 42e-10, 43e-10, 44e-10, 45e-10, 46e-10, 47e-10, 48e-10, 49e-10, 50e-10, 51e-10, 52e-10, 53e-10, 54e-10, 55e-10, 56e-10, 57e-10, 58e-10, 59e-10, 60e-10, 61e-10, 62e-10, 63e-10, 64e-10, 65e-10, 66e-10, 67e-10, 68e-10, 69e-10, 70e-10, 71e-10, 72e-10, 73e-10, 74e-10, 75e-10, 76e-10, 77e-10, 78e-10, 79e-10, 80e-10, 81e-10, 82e-10, 83e-10, 84e-10, 85e-10, 86e-10, 87e-10, 88e-10, 89e-10, 90e-10, 91e-10, 92e-10, 93e-10, 94e-10, 95e-10, 96e-10, 97e-10, 98e-10, 99e-10, 100e-10, 101e-10, 102e-10, 103e-10, 104e-10, 105e-10, 106e-10, 107e-10, 108e-10, 109e-10, 110e-10, 111e-10, 112e-10, 113e-10, 114e-10, 115e-10, 116e-10, 117e-10, 118e-10, 119e-10, 120e-10, 121e-10, 122e-10, 123e-10, 124e-10, 125e-10, 126e-10, 127e-10, 128e-10, 129e-10, 130e-10, 131e-10, 132e-10, 133e-10, 134e-10, 135e-10, 136e-10, 137e-10, 138e-10, 139e-10, 140e-10, 141e-10, 142e-10, 143e-10, 144e-10, 145e-10, 146e-10, 147e-10, 148e-10, 149e-10, 150e-10, 151e-10, 152e-10, 153e-10, 154e-10, 155e-10, 156e-10, 157e-10, 158e-10, 159e-10, 160e-10, 161e-10, 162e-10, 163e-10, 164e-10, 165e-10, 166e-10, 167e-10, 168e-10, 169e-10, 170e-10, 171e-10, 172e-10, 173e-10, 174e-10, 175e-10, 176e-10, 177e-10, 178e-10, 179e-10, 180e-10, 181e-10, 182e-10, 183e-10, 184e-10, 185e-10, 186e-10, 187e-10, 188e-10, 189e-10, 190e-10, 191e-10, 192e-10, 193e-10, 194e-10, 195e-10, 196e-10, 197e-10, 198e-10, 199e-10, 200e-10
//! analysis tran
//! print none
`include "check.vh"
module laplace_nd_slow_pole_holds_dc_gain(in, n);
  inout in, n;
  electrical in, n;
  real y;
  analog begin
    y = laplace_nd(V(in, n), '{0.625},
          '{1.0, 1.11111e-5, 1.12232211e-11, 1.123333211e-18, 1.12232211e-26, 1.11111e-35, 1e-45});
    `CHECK("a held input keeps the slow-pole filter at H(0)", y, 0.625, 1e-9);
    I(in, n) <+ 0.0;
  end
endmodule
