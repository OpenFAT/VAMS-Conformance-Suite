// AMS §4.2.4: "It shall be an error to pass zero (0) as the second argument
// to the modulus operator." §4.2.3: "All other operators shall not use
// short-circuit evaluation - all of their operand expressions are always
// evaluated", and only short-circuiting excuses a runtime error, so a
// remainder nobody reads is still evaluated and still an error.
// d=3 is legal and prints one verdict; d=0 is the error, so the run fails
// (with any status: §4.2.4 names none). VerA reports E0601 and exits 1.
// The legal unused-but-guarded neighbour is modulo_integer_short_circuit.va.
//! lrm 4.2.3
//! lrm 4.2.4
//! lrm 4.2.4:1
//! sweep V(p) = 3, 0
//! reject-run §4.2.4: a zero modulus divisor is an error
//! checks 1
//! print none
//! fd-exempt §4.2.4: the device stops with E0601 wherever round(V(p,n)) = 0, which L4b's random unknowns reach; stopping there is the rule this fixture pins
`include "check.vh"
module modulo_integer_unused_zero(p, n);
  inout p, n; electrical p, n;
  integer d, unused;
  analog begin
    d = V(p,n);
    unused = 11 % d;
    `CHECKI("only the nonzero point completes", d, 3);
    I(p,n) <+ V(p,n);
  end
endmodule
