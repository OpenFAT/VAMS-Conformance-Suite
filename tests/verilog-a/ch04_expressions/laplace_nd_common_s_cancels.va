// §4.5.11.4 laplace_nd filters whose denominator has d0 = 0, and the static
// point a transient starts from.
//
//   §4.5.11.4: "H(s) = (Σk=0..M-1 nk s^k) / (Σk=0..N-1 dk s^k)"
//   §4.5.11: "The Laplace transform filters implement lumped linear
//    continuous-time filters."
//
// With d0 = 0 the sum H(0) = n0/d0 is not the filter's DC value.
//
// (a) THE COMMON POWER OF s CANCELS. n = '{0, 1}, d = '{0, 1, tau}:
//     H(s) = s / (s + tau s^2) = 1 / (1 + tau s), so H(0) = 1 — a property
//     of the rational function, not a choice. Driven by the constant 0.5 V
//     the output is 0.5 at the DC point and stays 0.5.
//
// A pole at s = 0 (d = '{0, T}, an integrator) is not asserted: §4.5.11 does
// not say what a DC analysis returns for H(0) = infinity, so the integrator's
// starting value is the tool's.
//
// (b) A CONSISTENT START. n = '{1}, d = '{1, 2tau, tau^2}: H(0) = 1, and
//     driven by the constant 0.5 V from the operating point on, the output of
//     an LTI filter at its steady state is 0.5 at every time. A degree-2
//     section remembers two past samples; a static point that seeds only the
//     newest of them makes the first steps answer a step from 0 that the
//     input never took. Tolerance 1e-12.
//
// 21 points x 2 assertions = 42 verdicts.
//
//! lrm 4.5.11.4
//! lrm 4.5.11
//! lrm 4.5.11.4:1000
//! bias V(p) = 1
//! bias V(n) = 0
//! time 0, 0.5n, 1n, 1.5n, 2n, 2.5n, 3n, 3.5n, 4n, 4.5n, 5n, 5.5n, 6n, 6.5n, 7n, 7.5n, 8n, 8.5n, 9n, 9.5n, 10n
//! analysis tran
//! print none
//! checks 42
`include "check.vh"
module laplace_nd_common_s_cancels(p, n);
    inout p, n;
    electrical p, n;
    parameter real tau = 1e-8;

    analog begin
        `CHECK("a second-order section held at its DC input starts and stays at H(0)*u",
               laplace_nd(0.5 * V(p, n), '{1.0}, '{1.0, 2.0 * tau, tau * tau}), 0.5, 1e-12);
        `CHECK("s/(s + tau*s^2) has H(0) = 1 once the common s cancels",
               laplace_nd(0.5 * V(p, n), '{0.0, 1.0}, '{0.0, 1.0, tau}), 0.5, 1e-12);
        I(p, n) <+ 0.0;
    end
endmodule
