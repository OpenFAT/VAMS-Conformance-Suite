// §4.5.3 a ddt() that is NOT a linear factor of a contribution is still a time
// derivative the simulator integrates.
//
//   Table 4-17 ddt(expr): "Returns d/dt x(t), the time-derivative of x".
//   "In DC analysis, ddt() returns zero (0)."
//
//   §4.5.2: "Occasionally, analog operators require new equations and new
//   unknowns be introduced by the simulator to convert a module description
//   into a set of first-order differential equations."
//
// `x = ddt(V(p)); I(p) <+ x*x;` squares the derivative, so no contribution
// carries it as a charge (§5.6.1.2 strips a ddt only from a multiplicative
// spine). It is one new unknown s and one new equation s - d/dt V(p) = 0:
// the branch carries s*s.
//
// THE HAND DERIVATION. V(p) is driven 0, 1, 2 at t = 0, 0.5, 1, a straight line
// of slope 2 V/s after the DC point:
//
//   t     V(p)   ddt(V(p))
//   0     0      0     "In DC analysis, ddt() returns zero (0)"
//   0.5   1      2     (1 - 0) / 0.5
//   1     2      2     (2 - 1) / 0.5
//
// The derivative of a straight line is its slope whatever the step, and the
// testbench's backward-Euler difference reproduces it exactly on a linear
// segment. A rule that assumed the DC point's zero derivative carried into the
// first step would read something else there; the value the clause names is 2.
//
//! lrm 4.5.3
//! lrm 5.6.1.2
//! wave V(p) = 0, 1, 2
//! time 0, 0.5, 1
//! analysis tran
//! print none
`include "check.vh"
module ddt_in_expression_is_a_charge_site(p);
    inout p;
    electrical p;
    real x;

    analog begin
        x = ddt(V(p));
        I(p) <+ x * x;
        `CHECK("ddt of the driven ramp: 0 at DC, its slope 2 after", x, ($abstime > 0) * 2.0, 1e-12);
    end
endmodule
