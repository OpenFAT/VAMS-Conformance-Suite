// §4.5.13 limexp in the shape it exists for: the ideal-diode law. At a
// converged point limexp IS exp (§4.5.13: "the simulator can only converge
// when the output of limexp() equals the exponential of the input"), and the
// bias holds V(p, n) at 0.7, so the current is Is*(exp(V/Vt) - 1).
//
// Vt = kT/q. Annex D lists five vintages of k and q (`P_K_SPICE ... `P_K_NIST2018),
// and the LRM does not say which a simulator shall use, so the fixture must
// admit every one of them and nothing looser. At T = 300.15 K, kT/q is
//
//   SPICE     1.38062e-23   / 1.60219e-19     0.025864166734282455
//   OLD       1.3806226e-23 / 1.6021918e-19   0.02586418638455146
//   NIST2010  1.3806488e-23 / 1.602176565e-19 0.025864923153460305
//   NIST2018  1.380649e-23  / 1.602176634e-19 0.025864925786328753
//   NIST1998  1.3806503e-23 / 1.602176462e-19 0.025864952917090102
//
// The band midpoint is 0.0258645598 and its half-width is 1.520e-5 relative, so
// the want is that midpoint and RTOL is 1.6e-5 — the tightest number that still
// admits all five. (The previous 0.0258649 / 1e-4 pair sat near the top of the
// band and was 3.6x looser than the band it claimed to be "wide enough to admit
// — and nothing else".) A simulator that used 300 K instead of 300.15 is out by
// 5e-4, and one that dropped the temperature entirely by 4 orders of magnitude;
// both are excluded.
//
// At V = 0.7 V the exponent is 0.7/0.02586456 = 27.06, far below any limiting
// knee, so Id = 1e-14 * (exp(0.7/Vt) - 1). Pushing the same five Vt values
// through that exponential gives 0.0056701337 .. 0.0056748001, a band whose
// midpoint is 0.0056724669 and whose half-width is 4.113e-4 relative; RTOL is
// 4.2e-4. This is the assertion that bites: the exponential amplifies an error
// in Vt by a factor of 27, so a percent-level slip in Vt is a 30% slip in Id.
//
//! lrm 4.5.13
//! temp 300.15
//! bias V(p) = 0.7
//! bias V(n) = 0.0
`include "check.vh"
module ch04_limexp(p, n);
    inout p, n;
    electrical p, n;
    parameter real saturation_current = 1e-14;
    real id;

    analog begin
        id = saturation_current * (limexp(V(p, n) / $vt) - 1.0);

        `CHECKR("$vt is kT/q at 300.15 K", $vt, 0.0258645598, 1.6e-5);
        `CHECKR("limexp is exp below the limiting knee", limexp(1.0), 2.718281828459045, 1e-14);
        `CHECKR("ideal diode current at 0.7 V", id, 0.0056724669, 4.2e-4);

        I(p, n) <+ id;
    end
endmodule
