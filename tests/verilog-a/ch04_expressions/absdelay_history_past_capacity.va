// §4.5.7 states absdelay as a formula over all past time,
//
//     Output(t) = Input(max(t - td, 0))
//
// and bounds no lookback, so a delay of 1026 steps is the formula like any
// other. Whatever history a tool keeps, every lookback here must read the
// input at t - td.
//
// WHY 1026. VerA keeps each site's samples in a 1024-sample ring when there is
// no maxdelay, and thins it (every other sample in the older half) when it
// fills inside the window; a tool that dropped old samples instead would
// refuse these lookbacks. On a 1ns grid with td = 1026ns, VerA's ring fills at the
// commit of t = 1023ns (1024 samples, 0 .. 1023ns). Its second-oldest sample,
// 1ns, is later than 1023ns - 1026ns, so the oldest is still in the window:
// the ring keeps 0, 2, .., 510ns and 512 .. 1023ns, 768 samples. From then on
// a push drops the oldest sample only once the one after it has left the
// window, and thins again when it has not; the window [t - 1026ns, t] is
// always inside the ring, so no lookback is refused.
//
// THE ERROR BOUND. Linear interpolation over samples g apart is within
// g^2 * max|x''| / 8 of the input. The input here is the ramp $abstime*1e9,
// x'' = 0, so every lookback is exact: Output = max(t/1ns - 1026, 0), 0
// through t = 1026ns, then 1 .. 574 at t = 1027 .. 1600ns. Those lookbacks
// land on samples spaced 2ns apart (t - td < 512ns) and 1ns apart, so a ring
// that dropped instead of thinning would have refused all of them (the old
// E1012). The tolerance, 1e-6, covers the rounding of t*1e9 only.
//
//! lrm 4.5.7
//! bias V(n) = 0
//! checks 1601
//! time 0, 1n, 2n, 3n, 4n, 5n, 6n, 7n, 8n, 9n, 10n, 11n, 12n, 13n, 14n, 15n, 16n, 17n, 18n, 19n, 20n, 21n, 22n, 23n, 24n, 25n, 26n, 27n, 28n, 29n, 30n, 31n, 32n, 33n, 34n, 35n, 36n, 37n, 38n, 39n, 40n, 41n, 42n, 43n, 44n, 45n, 46n, 47n, 48n, 49n, 50n, 51n, 52n, 53n, 54n, 55n, 56n, 57n, 58n, 59n, 60n, 61n, 62n, 63n, 64n, 65n, 66n, 67n, 68n, 69n, 70n, 71n, 72n, 73n, 74n, 75n, 76n, 77n, 78n, 79n, 80n, 81n, 82n, 83n, 84n, 85n, 86n, 87n, 88n, 89n, 90n, 91n, 92n, 93n, 94n, 95n, 96n, 97n, 98n, 99n, 100n, 101n, 102n, 103n, 104n, 105n, 106n, 107n, 108n, 109n, 110n, 111n, 112n, 113n, 114n, 115n, 116n, 117n, 118n, 119n, 120n, 121n, 122n, 123n, 124n, 125n, 126n, 127n, 128n, 129n, 130n, 131n, 132n, 133n, 134n, 135n, 136n, 137n, 138n, 139n, 140n, 141n, 142n, 143n, 144n, 145n, 146n, 147n, 148n, 149n, 150n, 151n, 152n, 153n, 154n, 155n, 156n, 157n, 158n, 159n, 160n, 161n, 162n, 163n, 164n, 165n, 166n, 167n, 168n, 169n, 170n, 171n, 172n, 173n, 174n, 175n, 176n, 177n, 178n, 179n, 180n, 181n, 182n, 183n, 184n, 185n, 186n, 187n, 188n, 189n, 190n, 191n, 192n, 193n, 194n, 195n, 196n, 197n, 198n, 199n, 200n, 201n, 202n, 203n, 204n, 205n, 206n, 207n, 208n, 209n, 210n, 211n, 212n, 213n, 214n, 215n, 216n, 217n, 218n, 219n, 220n, 221n, 222n, 223n, 224n, 225n, 226n, 227n, 228n, 229n, 230n, 231n, 232n, 233n, 234n, 235n, 236n, 237n, 238n, 239n, 240n, 241n, 242n, 243n, 244n, 245n, 246n, 247n, 248n, 249n, 250n, 251n, 252n, 253n, 254n, 255n, 256n, 257n, 258n, 259n, 260n, 261n, 262n, 263n, 264n, 265n, 266n, 267n, 268n, 269n, 270n, 271n, 272n, 273n, 274n, 275n, 276n, 277n, 278n, 279n, 280n, 281n, 282n, 283n, 284n, 285n, 286n, 287n, 288n, 289n, 290n, 291n, 292n, 293n, 294n, 295n, 296n, 297n, 298n, 299n, 300n, 301n, 302n, 303n, 304n, 305n, 306n, 307n, 308n, 309n, 310n, 311n, 312n, 313n, 314n, 315n, 316n, 317n, 318n, 319n, 320n, 321n, 322n, 323n, 324n, 325n, 326n, 327n, 328n, 329n, 330n, 331n, 332n, 333n, 334n, 335n, 336n, 337n, 338n, 339n, 340n, 341n, 342n, 343n, 344n, 345n, 346n, 347n, 348n, 349n, 350n, 351n, 352n, 353n, 354n, 355n, 356n, 357n, 358n, 359n, 360n, 361n, 362n, 363n, 364n, 365n, 366n, 367n, 368n, 369n, 370n, 371n, 372n, 373n, 374n, 375n, 376n, 377n, 378n, 379n, 380n, 381n, 382n, 383n, 384n, 385n, 386n, 387n, 388n, 389n, 390n, 391n, 392n, 393n, 394n, 395n, 396n, 397n, 398n, 399n, 400n, 401n, 402n, 403n, 404n, 405n, 406n, 407n, 408n, 409n, 410n, 411n, 412n, 413n, 414n, 415n, 416n, 417n, 418n, 419n, 420n, 421n, 422n, 423n, 424n, 425n, 426n, 427n, 428n, 429n, 430n, 431n, 432n, 433n, 434n, 435n, 436n, 437n, 438n, 439n, 440n, 441n, 442n, 443n, 444n, 445n, 446n, 447n, 448n, 449n, 450n, 451n, 452n, 453n, 454n, 455n, 456n, 457n, 458n, 459n, 460n, 461n, 462n, 463n, 464n, 465n, 466n, 467n, 468n, 469n, 470n, 471n, 472n, 473n, 474n, 475n, 476n, 477n, 478n, 479n, 480n, 481n, 482n, 483n, 484n, 485n, 486n, 487n, 488n, 489n, 490n, 491n, 492n, 493n, 494n, 495n, 496n, 497n, 498n, 499n, 500n, 501n, 502n, 503n, 504n, 505n, 506n, 507n, 508n, 509n, 510n, 511n, 512n, 513n, 514n, 515n, 516n, 517n, 518n, 519n, 520n, 521n, 522n, 523n, 524n, 525n, 526n, 527n, 528n, 529n, 530n, 531n, 532n, 533n, 534n, 535n, 536n, 537n, 538n, 539n, 540n, 541n, 542n, 543n, 544n, 545n, 546n, 547n, 548n, 549n, 550n, 551n, 552n, 553n, 554n, 555n, 556n, 557n, 558n, 559n, 560n, 561n, 562n, 563n, 564n, 565n, 566n, 567n, 568n, 569n, 570n, 571n, 572n, 573n, 574n, 575n, 576n, 577n, 578n, 579n, 580n, 581n, 582n, 583n, 584n, 585n, 586n, 587n, 588n, 589n, 590n, 591n, 592n, 593n, 594n, 595n, 596n, 597n, 598n, 599n, 600n, 601n, 602n, 603n, 604n, 605n, 606n, 607n, 608n, 609n, 610n, 611n, 612n, 613n, 614n, 615n, 616n, 617n, 618n, 619n, 620n, 621n, 622n, 623n, 624n, 625n, 626n, 627n, 628n, 629n, 630n, 631n, 632n, 633n, 634n, 635n, 636n, 637n, 638n, 639n, 640n, 641n, 642n, 643n, 644n, 645n, 646n, 647n, 648n, 649n, 650n, 651n, 652n, 653n, 654n, 655n, 656n, 657n, 658n, 659n, 660n, 661n, 662n, 663n, 664n, 665n, 666n, 667n, 668n, 669n, 670n, 671n, 672n, 673n, 674n, 675n, 676n, 677n, 678n, 679n, 680n, 681n, 682n, 683n, 684n, 685n, 686n, 687n, 688n, 689n, 690n, 691n, 692n, 693n, 694n, 695n, 696n, 697n, 698n, 699n, 700n, 701n, 702n, 703n, 704n, 705n, 706n, 707n, 708n, 709n, 710n, 711n, 712n, 713n, 714n, 715n, 716n, 717n, 718n, 719n, 720n, 721n, 722n, 723n, 724n, 725n, 726n, 727n, 728n, 729n, 730n, 731n, 732n, 733n, 734n, 735n, 736n, 737n, 738n, 739n, 740n, 741n, 742n, 743n, 744n, 745n, 746n, 747n, 748n, 749n, 750n, 751n, 752n, 753n, 754n, 755n, 756n, 757n, 758n, 759n, 760n, 761n, 762n, 763n, 764n, 765n, 766n, 767n, 768n, 769n, 770n, 771n, 772n, 773n, 774n, 775n, 776n, 777n, 778n, 779n, 780n, 781n, 782n, 783n, 784n, 785n, 786n, 787n, 788n, 789n, 790n, 791n, 792n, 793n, 794n, 795n, 796n, 797n, 798n, 799n, 800n, 801n, 802n, 803n, 804n, 805n, 806n, 807n, 808n, 809n, 810n, 811n, 812n, 813n, 814n, 815n, 816n, 817n, 818n, 819n, 820n, 821n, 822n, 823n, 824n, 825n, 826n, 827n, 828n, 829n, 830n, 831n, 832n, 833n, 834n, 835n, 836n, 837n, 838n, 839n, 840n, 841n, 842n, 843n, 844n, 845n, 846n, 847n, 848n, 849n, 850n, 851n, 852n, 853n, 854n, 855n, 856n, 857n, 858n, 859n, 860n, 861n, 862n, 863n, 864n, 865n, 866n, 867n, 868n, 869n, 870n, 871n, 872n, 873n, 874n, 875n, 876n, 877n, 878n, 879n, 880n, 881n, 882n, 883n, 884n, 885n, 886n, 887n, 888n, 889n, 890n, 891n, 892n, 893n, 894n, 895n, 896n, 897n, 898n, 899n, 900n, 901n, 902n, 903n, 904n, 905n, 906n, 907n, 908n, 909n, 910n, 911n, 912n, 913n, 914n, 915n, 916n, 917n, 918n, 919n, 920n, 921n, 922n, 923n, 924n, 925n, 926n, 927n, 928n, 929n, 930n, 931n, 932n, 933n, 934n, 935n, 936n, 937n, 938n, 939n, 940n, 941n, 942n, 943n, 944n, 945n, 946n, 947n, 948n, 949n, 950n, 951n, 952n, 953n, 954n, 955n, 956n, 957n, 958n, 959n, 960n, 961n, 962n, 963n, 964n, 965n, 966n, 967n, 968n, 969n, 970n, 971n, 972n, 973n, 974n, 975n, 976n, 977n, 978n, 979n, 980n, 981n, 982n, 983n, 984n, 985n, 986n, 987n, 988n, 989n, 990n, 991n, 992n, 993n, 994n, 995n, 996n, 997n, 998n, 999n, 1000n, 1001n, 1002n, 1003n, 1004n, 1005n, 1006n, 1007n, 1008n, 1009n, 1010n, 1011n, 1012n, 1013n, 1014n, 1015n, 1016n, 1017n, 1018n, 1019n, 1020n, 1021n, 1022n, 1023n, 1024n, 1025n, 1026n, 1027n, 1028n, 1029n, 1030n, 1031n, 1032n, 1033n, 1034n, 1035n, 1036n, 1037n, 1038n, 1039n, 1040n, 1041n, 1042n, 1043n, 1044n, 1045n, 1046n, 1047n, 1048n, 1049n, 1050n, 1051n, 1052n, 1053n, 1054n, 1055n, 1056n, 1057n, 1058n, 1059n, 1060n, 1061n, 1062n, 1063n, 1064n, 1065n, 1066n, 1067n, 1068n, 1069n, 1070n, 1071n, 1072n, 1073n, 1074n, 1075n, 1076n, 1077n, 1078n, 1079n, 1080n, 1081n, 1082n, 1083n, 1084n, 1085n, 1086n, 1087n, 1088n, 1089n, 1090n, 1091n, 1092n, 1093n, 1094n, 1095n, 1096n, 1097n, 1098n, 1099n, 1100n, 1101n, 1102n, 1103n, 1104n, 1105n, 1106n, 1107n, 1108n, 1109n, 1110n, 1111n, 1112n, 1113n, 1114n, 1115n, 1116n, 1117n, 1118n, 1119n, 1120n, 1121n, 1122n, 1123n, 1124n, 1125n, 1126n, 1127n, 1128n, 1129n, 1130n, 1131n, 1132n, 1133n, 1134n, 1135n, 1136n, 1137n, 1138n, 1139n, 1140n, 1141n, 1142n, 1143n, 1144n, 1145n, 1146n, 1147n, 1148n, 1149n, 1150n, 1151n, 1152n, 1153n, 1154n, 1155n, 1156n, 1157n, 1158n, 1159n, 1160n, 1161n, 1162n, 1163n, 1164n, 1165n, 1166n, 1167n, 1168n, 1169n, 1170n, 1171n, 1172n, 1173n, 1174n, 1175n, 1176n, 1177n, 1178n, 1179n, 1180n, 1181n, 1182n, 1183n, 1184n, 1185n, 1186n, 1187n, 1188n, 1189n, 1190n, 1191n, 1192n, 1193n, 1194n, 1195n, 1196n, 1197n, 1198n, 1199n, 1200n, 1201n, 1202n, 1203n, 1204n, 1205n, 1206n, 1207n, 1208n, 1209n, 1210n, 1211n, 1212n, 1213n, 1214n, 1215n, 1216n, 1217n, 1218n, 1219n, 1220n, 1221n, 1222n, 1223n, 1224n, 1225n, 1226n, 1227n, 1228n, 1229n, 1230n, 1231n, 1232n, 1233n, 1234n, 1235n, 1236n, 1237n, 1238n, 1239n, 1240n, 1241n, 1242n, 1243n, 1244n, 1245n, 1246n, 1247n, 1248n, 1249n, 1250n, 1251n, 1252n, 1253n, 1254n, 1255n, 1256n, 1257n, 1258n, 1259n, 1260n, 1261n, 1262n, 1263n, 1264n, 1265n, 1266n, 1267n, 1268n, 1269n, 1270n, 1271n, 1272n, 1273n, 1274n, 1275n, 1276n, 1277n, 1278n, 1279n, 1280n, 1281n, 1282n, 1283n, 1284n, 1285n, 1286n, 1287n, 1288n, 1289n, 1290n, 1291n, 1292n, 1293n, 1294n, 1295n, 1296n, 1297n, 1298n, 1299n, 1300n, 1301n, 1302n, 1303n, 1304n, 1305n, 1306n, 1307n, 1308n, 1309n, 1310n, 1311n, 1312n, 1313n, 1314n, 1315n, 1316n, 1317n, 1318n, 1319n, 1320n, 1321n, 1322n, 1323n, 1324n, 1325n, 1326n, 1327n, 1328n, 1329n, 1330n, 1331n, 1332n, 1333n, 1334n, 1335n, 1336n, 1337n, 1338n, 1339n, 1340n, 1341n, 1342n, 1343n, 1344n, 1345n, 1346n, 1347n, 1348n, 1349n, 1350n, 1351n, 1352n, 1353n, 1354n, 1355n, 1356n, 1357n, 1358n, 1359n, 1360n, 1361n, 1362n, 1363n, 1364n, 1365n, 1366n, 1367n, 1368n, 1369n, 1370n, 1371n, 1372n, 1373n, 1374n, 1375n, 1376n, 1377n, 1378n, 1379n, 1380n, 1381n, 1382n, 1383n, 1384n, 1385n, 1386n, 1387n, 1388n, 1389n, 1390n, 1391n, 1392n, 1393n, 1394n, 1395n, 1396n, 1397n, 1398n, 1399n, 1400n, 1401n, 1402n, 1403n, 1404n, 1405n, 1406n, 1407n, 1408n, 1409n, 1410n, 1411n, 1412n, 1413n, 1414n, 1415n, 1416n, 1417n, 1418n, 1419n, 1420n, 1421n, 1422n, 1423n, 1424n, 1425n, 1426n, 1427n, 1428n, 1429n, 1430n, 1431n, 1432n, 1433n, 1434n, 1435n, 1436n, 1437n, 1438n, 1439n, 1440n, 1441n, 1442n, 1443n, 1444n, 1445n, 1446n, 1447n, 1448n, 1449n, 1450n, 1451n, 1452n, 1453n, 1454n, 1455n, 1456n, 1457n, 1458n, 1459n, 1460n, 1461n, 1462n, 1463n, 1464n, 1465n, 1466n, 1467n, 1468n, 1469n, 1470n, 1471n, 1472n, 1473n, 1474n, 1475n, 1476n, 1477n, 1478n, 1479n, 1480n, 1481n, 1482n, 1483n, 1484n, 1485n, 1486n, 1487n, 1488n, 1489n, 1490n, 1491n, 1492n, 1493n, 1494n, 1495n, 1496n, 1497n, 1498n, 1499n, 1500n, 1501n, 1502n, 1503n, 1504n, 1505n, 1506n, 1507n, 1508n, 1509n, 1510n, 1511n, 1512n, 1513n, 1514n, 1515n, 1516n, 1517n, 1518n, 1519n, 1520n, 1521n, 1522n, 1523n, 1524n, 1525n, 1526n, 1527n, 1528n, 1529n, 1530n, 1531n, 1532n, 1533n, 1534n, 1535n, 1536n, 1537n, 1538n, 1539n, 1540n, 1541n, 1542n, 1543n, 1544n, 1545n, 1546n, 1547n, 1548n, 1549n, 1550n, 1551n, 1552n, 1553n, 1554n, 1555n, 1556n, 1557n, 1558n, 1559n, 1560n, 1561n, 1562n, 1563n, 1564n, 1565n, 1566n, 1567n, 1568n, 1569n, 1570n, 1571n, 1572n, 1573n, 1574n, 1575n, 1576n, 1577n, 1578n, 1579n, 1580n, 1581n, 1582n, 1583n, 1584n, 1585n, 1586n, 1587n, 1588n, 1589n, 1590n, 1591n, 1592n, 1593n, 1594n, 1595n, 1596n, 1597n, 1598n, 1599n, 1600n
//! analysis tran
//! print none
`include "check.vh"
module absdelay_history_past_capacity(p, n);
  inout p, n; electrical p, n;
  analog begin
    `CHECK("Input(max(t - td, 0)) past the 1024-sample ring, less max(t/1ns - 1026, 0)",
           absdelay($abstime * 1e9, 1026n) - max($abstime * 1e9 - 1026.0, 0.0), 0.0, 1e-6);
    I(p, n) <+ 0.0;
  end
endmodule
