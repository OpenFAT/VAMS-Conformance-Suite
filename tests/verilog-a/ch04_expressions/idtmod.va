// §4.5.5 circular integrator. Two things the LRM states outright:
//
//   "The output of the idtmod() function shall remain in the range
//    offset <= idtmod < offset+modulus"
//
//   "y = idt(expr, ic); z = idtmod(expr, ic, modulus, offset);
//    then y = n * modulus + z   // n is an integer"
//
// Both are checked against a CONSTANT integrand, 0.9e9, so the exact integral
// is 0.9e9*t and no integration formula can disagree: the trapezoidal rule and
// backward Euler both integrate a constant exactly. With modulus 2 and 1 ns
// steps the running integral is 0, 0.9, 1.8, 2.7, 3.6, 4.5 and the circular
// integrator must answer 0, 0.9, 1.8, 0.7, 1.6, 0.5 — three wraps, and never
// within 0.2 of a wrap boundary, so nothing here rides on a rounding.
//
// The FIRST check is against a closed form written in $abstime and nothing
// else — 0.9e9*t reduced modulo 2 — so the want is a literal 0.0 that no error
// shared with another operator can satisfy. The idt-vs-idtmod relation the LRM
// states, `y = n*modulus + z`, is a claim about two VerA expressions agreeing
// and is therefore a CHECKEQ: an error common to idt and idtmod passes it.
// A plain idt substituted for idtmod fails both from t = 3ns on, and fails the
// range check too.
//
// Table 4-19 gives idtmod six argument shapes; the ones below the four-argument
// form are pinned by the defaults 4.5.5 states in prose:
//
//   "The default for offset shall be zero (0)."
//     -> idtmod(x, ic, modulus) is idtmod(x, ic, modulus, 0.0)
//   "If the modulus is not specified, then idtmod() shall behave like idt()
//    and not limit the output of the integrator."
//     -> idtmod(x, ic) is idt(x, ic)
//
// Both are identities between two VerA expressions with no digits of their own,
// so both are CHECKEQ. The one-argument idtmod(expr) is written into the
// contribution but not asserted here. §4.5.5's prose requires its constant
// to default to zero ("If the initial condition is not specified, it defaults
// to zero (0)"), and idtmod_one_argument_starts_at_zero.va asserts that.
//
//! lrm 4.5.5
//! lrm 4.5.5:3
//! lrm 4.5.5:4
//! lrm 4.5.5:5
//! lrm 4.5.5:6
//! analysis tran
//! time 0, 1n, 2n, 3n, 4n, 5n
//! print none
`include "check.vh"
module ch04_idtmod(p, n);
    inout p, n;
    electrical p, n;

    analog begin
        // The exact integral of a constant, reduced modulo 2, from $abstime
        // alone. One literal want, true at all six time points.
        `CHECK("idtmod of a constant integrand is 0.9e9*t reduced modulo 2",
               idtmod(0.9e9, 0.0, 2.0, 0.0) -
               (0.9e9 * $abstime - 2.0 * floor(0.9e9 * $abstime / 2.0)), 0.0, 1e-9);
        `CHECKI("output stays in [offset, offset+modulus)",
                (idtmod(0.9e9, 0.0, 2.0, 0.0) >= 0.0) && (idtmod(0.9e9, 0.0, 2.0, 0.0) < 2.0), 1);
        `CHECKEQ("idtmod is idt reduced modulo the modulus",
                 idtmod(0.9e9, 0.0, 2.0, 0.0),
                 idt(0.9e9, 0.0) - 2.0 * floor(idt(0.9e9, 0.0) / 2.0), 1e-9);
        `CHECKEQ("a missing offset defaults to zero",
                 idtmod(0.9e9, 0.0, 2.0), idtmod(0.9e9, 0.0, 2.0, 0.0), 1e-12);
        `CHECKEQ("a missing modulus makes idtmod behave like idt",
                 idtmod(0.9e9, 0.0), idt(0.9e9, 0.0), 1e-9);
        `CHECK("a nonzero negative offset shifts the wrapping interval",
               idtmod(0.9e9, 0.0, 2.0, -1.0) -
               (0.9e9 * $abstime - 2.0 * floor((0.9e9 * $abstime + 1.0) / 2.0)),
               0.0, 1e-9);
        `CHECKI("the negative-offset result remains in minus-one inclusive to one exclusive",
                idtmod(0.9e9, 0.0, 2.0, -1.0) >= -1.0 &&
                idtmod(0.9e9, 0.0, 2.0, -1.0) < 1.0, 1);

        V(p, n) <+ idtmod(I(p, n), 0.0, 6.283185307179586, 0.0) + idtmod(I(p, n));
    end
endmodule
