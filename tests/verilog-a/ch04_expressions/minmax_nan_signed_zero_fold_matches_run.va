// AMS 4.3.1: "these functions are defined so: min(x,y) is equivalent to
// (x < y) ? x : y max(x,y) is equivalent to (x > y) ? x : y". Table 4-14
// gives both the domain "All x, all y", so a NaN or a signed zero is a legal
// operand and the conditional form decides the result. §3.2 makes a real
// "as described by IEEE Std 754", so by hand, with N a NaN (every comparison
// with it is false) and -0 < +0 false (IEEE 754 5.11):
//   min(1, N) = N      min(N, 1) = 1      max(1, N) = N      max(N, 1) = 1
//   min(-0, +0) = +0   min(+0, -0) = -0   max(-0, +0) = +0   max(+0, -0) = -0
// The same eight are taken three ways: folded at compile time (a localparam),
// computed by the host from the card (a parameter), and computed by eval
// (from the probe V(p,n) = 0). All three must give the same bits. N is
// inf - inf, inf being 1e308*10 (overflow); a zero's sign is read as the sign
// of 1/z. There is no invalid input to pair: the domain is all x, all y.
//! lrm 4.3.1
//! bias V(p) = 0, V(n) = 0
//! checks 24
`include "check.vh"
module minmax_nan_signed_zero_fold_matches_run(p, n);
  inout p, n; electrical p, n;
  localparam real lbig = 1e308 * 10.0;
  localparam real lnan = lbig - lbig;
  localparam real lz = 0.0;
  localparam real lnz = -lz;
  parameter real big = 1e308;
  parameter real pz = 0.0;
  real pnan, pnz, rhi, rnan, rz, rnz;
  analog begin
    pnan = big * 10.0 - big * 10.0;
    pnz = -pz;
    rhi = (V(p,n) + 1e308) * 10.0;
    rnan = rhi - rhi;
    rz = V(p,n);
    rnz = -V(p,n);
    `CHECKI("fold min(1,N) is N", min(1.0, lnan) != min(1.0, lnan), 1);
    `CHECKX("fold min(N,1) is 1", min(lnan, 1.0), 1.0);
    `CHECKI("fold max(1,N) is N", max(1.0, lnan) != max(1.0, lnan), 1);
    `CHECKX("fold max(N,1) is 1", max(lnan, 1.0), 1.0);
    `CHECKI("fold min(-0,+0) is +0", 1.0 / min(lnz, lz) > 0.0, 1);
    `CHECKI("fold min(+0,-0) is -0", 1.0 / min(lz, lnz) < 0.0, 1);
    `CHECKI("fold max(-0,+0) is +0", 1.0 / max(lnz, lz) > 0.0, 1);
    `CHECKI("fold max(+0,-0) is -0", 1.0 / max(lz, lnz) < 0.0, 1);
    `CHECKI("card min(1,N) is N", min(1.0, pnan) != min(1.0, pnan), 1);
    `CHECKX("card min(N,1) is 1", min(pnan, 1.0), 1.0);
    `CHECKI("card max(1,N) is N", max(1.0, pnan) != max(1.0, pnan), 1);
    `CHECKX("card max(N,1) is 1", max(pnan, 1.0), 1.0);
    `CHECKI("card min(-0,+0) is +0", 1.0 / min(pnz, pz) > 0.0, 1);
    `CHECKI("card min(+0,-0) is -0", 1.0 / min(pz, pnz) < 0.0, 1);
    `CHECKI("card max(-0,+0) is +0", 1.0 / max(pnz, pz) > 0.0, 1);
    `CHECKI("card max(+0,-0) is -0", 1.0 / max(pz, pnz) < 0.0, 1);
    `CHECKI("run min(1,N) is N", min(1.0, rnan) != min(1.0, rnan), 1);
    `CHECKX("run min(N,1) is 1", min(rnan, 1.0), 1.0);
    `CHECKI("run max(1,N) is N", max(1.0, rnan) != max(1.0, rnan), 1);
    `CHECKX("run max(N,1) is 1", max(rnan, 1.0), 1.0);
    `CHECKI("run min(-0,+0) is +0", 1.0 / min(rnz, rz) > 0.0, 1);
    `CHECKI("run min(+0,-0) is -0", 1.0 / min(rz, rnz) < 0.0, 1);
    `CHECKI("run max(-0,+0) is +0", 1.0 / max(rnz, rz) > 0.0, 1);
    `CHECKI("run max(+0,-0) is -0", 1.0 / max(rz, rnz) < 0.0, 1);
    I(p,n) <+ V(p,n);
  end
endmodule
