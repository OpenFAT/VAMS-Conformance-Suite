// A device with a §9.7.3 severity task AND a §4.6.4 noise source.
//
// §4.6.4.1: white_noise(pwr) "generates a frequency-independent noise of
// power pwr", and a §9.7.3 severity task that never runs changes nothing.
// (VerA once failed to compile a device holding both, since the task's status
// channel and the noise evaluation disagreed about the instance; the
// `//! noise` line makes the testbench evaluate the noise.)
//
// The `$error` guard is never taken (R = 1 kOhm > 0), so the status stays 0
// and every number is the plain resistor's. The transcript has 5 verdicts:
// the `//! noise` line's count, branch, name and white power, and the CHECKR.
//
//   white = 4 · P_K · 300 / 1000 = 4 · 1.3806503e-23 · 300 / 1000
//         = 1.65678036e-23 A²/Hz   (annex D.2 `P_K_NIST1998`, `//! temp 300`)
//   I(p,n) = V(p,n) / R = 1.0 / 1000 = 1e-3 A
//
//! lrm 4.6.4.1
//! lrm 9.7.3
//! noise thermal(p,n)#0 name=thermal white=1.65678036e-23
//! analysis noise
//! temp 300.0
//! bias V(p) = 1.0
//! bias V(n) = 0.0
//! checks 5
`include "check.vh"
module status_site_beside_noise(p, n);
    inout p, n;
    electrical p, n;
    parameter real R = 1000.0;

    analog begin
        if (R <= 0.0) $error("R must be positive, got %g", R);
        `CHECKR("the dc current is the resistive term alone", V(p, n) / R, 1e-3, 1e-15);
        I(p, n) <+ V(p, n) / R + white_noise(4.0 * `P_K * $temperature / R, "thermal");
    end
endmodule
