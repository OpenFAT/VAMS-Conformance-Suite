// §4.6.1 Table 4-22, the TRAN column's two halves, which analysis_transient.va
// leaves out. Table 4-21: "ic" is "The initial-condition analysis which
// precedes a transient analysis"; "static" is "Any equilibrium point
// calculation, including ... the IC analysis which precedes a transient
// analysis". Table 4-22 reads, per row, TRAN OP then Tran:
//
//     "static"  1  0
//     "ic"      1  0
//     "dc"      0  0
//     "tran"    1  1
//
// ("nodeset" is 1 only during the part of the OP "when nodesets are applied";
// whether any evaluation falls in that part is the solver's, so it is not
// asserted.)
// The grid's t = 0 point is the TRAN OP: it is solved with dt = 0, the
// operating point the transient starts from; 1n and 2n are Tran points. So
// at t = 0 "static" and "ic" are 1, and at 1n and 2n both are 0: the want is
// `$abstime == 0`.
//
// §5.10.2: initial_step with a list fires "on the first point" of an
// analysis when "any string matches the name of the current analysis".
// The first point of this transient is the TRAN OP, where (above) "static",
// "ic" and "tran" match and "dc" does not (Table 5-1 TRAN OP:
// initial_step("tran") 1, initial_step("dc") 0). Each body counts, so a
// count of 1 at every point says it fired at the OP and never again.
//
// Checks: 8 per point x 3 points = 24.
//
// Issue #53: every point here was evaluated as "tran", so "static"/"ic" read 0
// at t = 0 and initial_step("static")/("ic") never fired.
//
//! lrm 4.6.1
//! lrm 4.6.1:1003
//! lrm 5.10.2
//! analysis tran
//! time 0, 1n, 2n
//! checks 24
`include "check.vh"
module ch04_tran_op_is_ic_and_static(p, n);
    inout p, n;
    electrical p, n;
    integer n_static, n_ic, n_tran, n_dc;

    analog begin
        @(initial_step("static")) n_static = n_static + 1;
        @(initial_step("ic"))     n_ic     = n_ic + 1;
        @(initial_step("tran"))   n_tran   = n_tran + 1;
        @(initial_step("dc"))     n_dc     = n_dc + 1;

        `CHECKI("analysis(\"static\") is 1 at the TRAN OP only", analysis("static"), $abstime == 0);
        `CHECKI("analysis(\"ic\") is 1 at the TRAN OP only", analysis("ic"), $abstime == 0);
        `CHECKI("analysis(\"tran\") is 1 at every point", analysis("tran"), 1);
        `CHECKI("analysis(\"dc\") is 0 at every point", analysis("dc"), 0);
        `CHECKI("initial_step(\"static\") fired once, at the TRAN OP", n_static, 1);
        `CHECKI("initial_step(\"ic\") fired once, at the TRAN OP", n_ic, 1);
        `CHECKI("initial_step(\"tran\") fired once, at the TRAN OP", n_tran, 1);
        `CHECKI("initial_step(\"dc\") never fires in a transient", n_dc, 0);
        I(p, n) <+ V(p, n);
    end
endmodule
