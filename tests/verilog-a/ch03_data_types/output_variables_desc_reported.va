// Host-only design for vera/host/opvars_host.zig: the operating-point
// variables a device reports. OSDI defines one as a module-scope variable
// with a §2.9.2 `desc` attribute (§3.2.1 calls such a variable an output
// variable a simulator may report); a `units` attribute alone does not make
// one, and neither does a plain variable. The host checks the names in
// declaration order and each value against this module's own equations by
// hand: ir = V(a, c) / r, g = d(ir)/dV(a) = 1/r, region 2 above 0.5 V and 1
// at or below it, and idle, never assigned, at its zero start.
`include "disciplines.vams"
module output_variables_desc_reported(a, c);
    inout a, c;
    electrical a, c;
    parameter real r = 1e3;
    (* desc = "Resistor current", units = "A" *) real ir;
    (* desc = "Small-signal conductance", units = "S" *) real g;
    (* desc = "Bias region" *) integer region;
    (* units = "V" *) real vonly;
    real scratch;
    (* desc = "Never assigned" *) real idle;

    analog begin
        scratch = V(a, c);
        ir = scratch / r;
        g = ddx(ir, V(a));
        if (scratch > 0.5)
            region = 2;
        else
            region = 1;
        vonly = scratch;
        I(a, c) <+ ir;
    end
endmodule
