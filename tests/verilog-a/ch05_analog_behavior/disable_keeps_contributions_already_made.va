// §5.6.1.3: "When solving an analog block during an iteration, multiple
// contributions to the same potential branch or same flow branch will be
// additive." A.6.5's `disable` transfers control out of the named block
// (IEEE 1364-2005 9.6.2, inherited); no clause undoes a statement that
// already ran, so a contribution made before the `disable` stands and only
// the ones after it are skipped.
//
// §5.6.1.3: "Unlike variables, the contributed value for a branch is only
// valid for the current iteration." The check at 1n is the observation: the
// -1 A contributed during the time-zero solve is not carried into the next
// solve — if it were (as a variable written in an analog block would be), the
// node equation there would read V(m) - 1 - 1 - 2 = 0 and V(m) = 4, not 3.
//
// The circuit: node m to ground through 1 S (I(m) <+ V(m)), and inside block
// b two sources pulling 1 A and then 2 A out of m (I(m) <+ -1, I(m) <+ -2).
// `@(initial_step) disable b;` sits between them. KCL at m, solved:
//   at 0 (the initial step): V(m) - 1 = 0, so V(m) = 1, the first source
//     alone (withdrawing it would give 0; ignoring the disable, 3);
//   at 1n: no event, both sources run: V(m) - 1 - 2 = 0, V(m) = 3.
// Ports p, n carry a plain 1 kohm so the bias has a branch. The invalid
// neighbour, a `disable` that is not in an event statement, is
// annex_a_syntax/disable_statement.va (E0401).
//! lrm 5.6.1.3
//! lrm 5.6.1.3:1003
//! lrm A.6.5
//! analysis tran
//! time 0, 1n
//! bias V(p) = 0, V(n) = 0
//! solve
//! checks 2
`include "check.vh"
module disable_keeps_contributions_already_made(p, n);
  inout p, n;
  electrical p, n, m;
  analog begin
    I(p, n) <+ V(p, n) / 1k;
    I(m) <+ V(m);
    begin : b
      I(m) <+ -1.0;
      @(initial_step) disable b;
      I(m) <+ -2.0;
    end
    `CHECK("contributions made before the disable stand", V(m), ($abstime == 0.0) ? 1.0 : 3.0, 1e-12);
  end
endmodule
