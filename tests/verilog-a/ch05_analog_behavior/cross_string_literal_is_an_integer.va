// §2.7: "A string literal used as an operand in expressions and assignments
// shall be treated as unsigned integer constants represented by a sequence of
// 8-bit ASCII values". So in `cross("s")` the monitored expression is the
// constant 0x73 = 115, which never crosses zero: the event never fires and
// `fired` keeps §3.2's 0 at every point.
//
// The control is cross(V(p)) on the wave -1, 1, 1 over 0, 1n, 2n: one rising
// crossing strictly between 0 and 1n, so on the fixed grid it fires at the
// first point past it (event_cross_rising_and_falling.va explains the grid),
// and `control` reads 0, 1, 1.
//
//   t     V(p)  fired  control
//   0     -1    0      0
//   1n     1    0      1
//   2n     1    0      1
//
// Two verdicts at three points. reject_5_10_3_cross_string_operand.va monitors
// a string VARIABLE instead, a §3.3 string type with no number to cross.
//
//! lrm 5.10.3.1
//! lrm 2.7
//! lrm 2.7:1
//! analysis tran
//! time 0, 1n, 2n
//! wave V(p) = -1, 1, 1
//! checks 6
`include "check.vh"
module ch5_cross_string_operand(p);
  inout p; electrical p; integer fired, control;
  analog begin
    @(cross("s")) fired = fired + 1;
    @(cross(V(p))) control = control + 1;
    `CHECKI("cross of the literal s monitors the constant 115 and never fires", fired, 0);
    `CHECKI("cross(V(p)) fires once, at the first point past its crossing", control, ($abstime > 0.5n) ? 1 : 0);
    I(p) <+ V(p);
  end
endmodule
