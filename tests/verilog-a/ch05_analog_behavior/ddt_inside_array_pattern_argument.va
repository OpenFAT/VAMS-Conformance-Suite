// §4.5.3 Table 4-17 ddt(expr): "Returns d/dt x(t), the time-derivative of x".
// `ddt(V(p, n))` below is legal source: it is an ordinary operand of an A.8.1
// assignment pattern, the `input` array actual of a §4.7.2.3 function call,
// and `first` returns it unchanged — so the branch carries the current
// d/dt V(p,n), a 1 F capacitor.
//
// The ddt is not a factor of the contribution, so no charge can be stripped
// from the right-hand side. §4.5.2 provides for exactly this: "Occasionally,
// analog operators require new equations and new unknowns be introduced by the
// simulator to convert a module description into a set of first-order
// differential equations." The ddt is one new unknown s and one new equation
// s - d/dt V(p,n) = 0, and the branch carries first('{s, 0.0}) = s.
//
// The CHECK pins that `first` returns element 0 of its pattern, on the same
// shape without the ddt: V(p,n) = 1.0 at the declared bias.
//
//! lrm 4.5.3
//! lrm 4.5.2
//! bias V(p) = 1.0, V(n) = 0.0
//! print none
`include "disciplines.vams"
`include "check.vh"
module ch5_ddt_inside_array_pattern(p, n);
  inout p, n; electrical p, n;
  analog function real first;
    input [0:1] a;
    real a[0:1];
    begin
      first = a[0];
    end
  endfunction
  analog begin
    `CHECKX("first returns element 0 of its pattern", first('{V(p, n), 0.0}), 1.0);
    I(p, n) <+ first('{ddt(V(p, n)), 0.0});
  end
endmodule
