// §3.12.1: "A port branch is a special type of branch used to access the
// flow into a port of a module (see 5.4.3). It is a branch between the upper
// and lower connections of the port." So `I(pb)` over `branch (<a>) pb;`
// names the same quantity as `I(<a>)`: read inside an instance, the flow
// into that instance's own port. The port-branch spelling of
// port_access_own_port_inside_instance.va.
//
// BY HAND, at the bias V(p) = 0.5, each leaf `I(a) <+ V(a) / r`:
//   u1 (r = 2k): I(pb) = 0.5 / 2000 = 2.5e-4
//   u2 (r = 1k): I(pb) = 0.5 / 1000 = 5.0e-4
// A tool that read the joined net's (the top port's) flow would give 7.5e-4
// for both. Two checks.
//
//! lrm 3.12.1
//! lrm 5.4.3
//! bias V(p) = 0.5
//! solve
//! checks 2
`include "check.vh"
module pbop_g(a);
  inout a; electrical a;
  parameter real r = 1k;
  parameter real want = 0.0;
  branch (<a>) pb;
  analog begin
    I(a) <+ V(a) / r;
    `CHECKR("the port branch carries the instance's own port flow", I(pb), want, 1e-12);
  end
endmodule
module pbop_top(p);
  inout p; electrical p;
  pbop_g #(.r(2k), .want(2.5e-4)) u1(p);
  pbop_g #(.r(1k), .want(5.0e-4)) u2(p);
endmodule
