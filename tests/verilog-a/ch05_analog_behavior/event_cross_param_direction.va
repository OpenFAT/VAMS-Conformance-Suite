// §5.10.3.1 the direction argument of cross() is an analog_expression, and a
// PARAMETER is one — so the direction in force is the model card's, not the
// declared default. §3.4 makes the override the parameter's value everywhere
// it is read; a compiler that folds the direction at code generation freezes
// the declared +1 into the comparison and this override never happens.
//
// V(p) is walked 0 -> 1 -> 2: one RISING crossing, no falling one. The
// declared default dir = +1 would fire on it and sample x = 1; the override
// dir = -1 ("the event ... only occur[s] on falling edge transitions") must
// stay silent, leaving x at the 0.0 a real variable starts with (§3.2). So
// x == 0.0 is precisely "the override reached the direction decode".
//
// Transient on purpose: §5.10.3.1 gives cross() no events outside transient
// analyses, so under dc this fixture would pin nothing (see
// event_cross_falling.va, whose literal-direction twin this is).
//
//! lrm 5.10.3.1
//! lrm 3.4
//! param dir = -1
//! analysis tran
//! time 0, 1n, 2n
//! wave V(p) = 0, 1, 2
`include "check.vh"
module ch5_cross_param_dir(p);
  inout p; electrical p; real x;
  parameter integer dir = 1 from [-1:1];
  analog begin
    @(cross(V(p), dir)) x = V(p);
    `CHECK("an overridden direction ignores the rising crossing", x, 0.0, 0.0);
    I(p) <+ x;
  end
endmodule
