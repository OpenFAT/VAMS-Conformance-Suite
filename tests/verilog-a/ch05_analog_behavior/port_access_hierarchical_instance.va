// §5.4.3: "The port access function accesses the flow into a port of a
// module." A.8.9 lets the port be hierarchical (`analog_port_reference ::=
// hierarchical_port_identifier`), and §6.7.1: "flow access for ... port
// branches can be done hierarchically". So `I(<u1.a>)` is the flow into the
// instance u1 through its own port a: what u1 conducts away from the net its
// port is joined to, and nothing any other instance on that net conducts.
//
// THE CIRCUIT. Two leaves on the top's port p, each `I(a) <+ V(a) / r`: u1 with
// r = 2k, u2 with r = 1k. Both write the unnamed branch (a, ground), so after
// flattening both contribute to the one pair (p, ground); each instance's own
// share is still its own branch (§5.4.1 "only one unnamed branch between any
// two nets" is a per-module rule, §5.6.8.1).
//
// BY HAND, at the bias V(p) = 0.5:
//   I(<u1.a>) = 0.5 / 2000 = 2.5e-4
//   I(<u2.a>) = 0.5 / 1000 = 5.0e-4
// and the top's own port flow is everything at p, I(<p>) = 7.5e-4. A tool
// that read the instance port as the net's (the top port's) flow would give
// 7.5e-4 for both. `//! solve` frees the top's port-flow unknown so Kirchhoff
// sets it. Three checks.
//
// port_access_hierarchical_potential_source.va is the same read of an
// instance driving its port through a potential source.
//
//! lrm 5.4.3
//! lrm 5.4.3:1002
//! lrm 6.7.1
//! bias V(p) = 0.5
//! solve
//! checks 3
`include "check.vh"
module pah_g(a);
  inout a; electrical a;
  parameter real r = 1k;
  analog I(a) <+ V(a) / r;
endmodule
module pah_top(p);
  inout p; electrical p;
  pah_g #(.r(2k)) u1(p);
  pah_g #(.r(1k)) u2(p);
  analog begin
    `CHECKR("the flow into u1 through its port a is u1's own", I(<u1.a>), 2.5e-4, 1e-12);
    `CHECKR("u2's port, on the same net, carries u2's own", I(<u2.a>), 5.0e-4, 1e-12);
    `CHECKR("the top's own port carries both", I(<p>), 7.5e-4, 1e-12);
  end
endmodule
