// §5.4.3: "The port access function accesses the flow into a port of a
// module ... I(<a>) accesses the current through module port a." Inside an
// instance, a module's own `I(<a>)` is the flow into THAT instance's port a:
// what the instance conducts away from the net the port is joined to, not
// the flow into the port of the module above it.
//
// THE CIRCUIT. Two leaves on the top's port p, each `I(a) <+ V(a) / r`: u1
// with r = 2k, u2 with r = 1k.
//
// BY HAND, at V(p) = 0.5: inside u1, I(<a>) = 0.5 / 2000 = 2.5e-4; inside u2,
// 0.5 / 1000 = 5e-4. Each is its own V(a) / r, so the check is that relation,
// once per instance; the top's port flow, 7.5e-4, would fail both. Two checks.
//
// port_access_hierarchical_instance.va reads the same two flows from the top
// as `I(<u1.a>)`, `I(<u2.a>)`.
//
//! lrm 5.4.3
//! bias V(p) = 0.5
//! solve
//! checks 2
`include "check.vh"
module paop_g(a);
  inout a; electrical a;
  parameter real r = 1k;
  analog begin
    I(a) <+ V(a) / r;
    `CHECKEQ("an instance's own port flow is its own V(a) / r", I(<a>), V(a) / r, 1e-12);
  end
endmodule
module paop_top(p);
  inout p; electrical p;
  paop_g #(.r(2k)) u1(p);
  paop_g #(.r(1k)) u2(p);
endmodule
