// §10.4 hands `define and `undef to IEEE Std 1364. Its §19.3.2: "An undefined
// text macro has no value, just as if it had never been defined." No clause
// makes the use itself an error, but either reading leaves `<+ *V(p,n)` (or an
// unexpanded `MISSING token), which A.6.10 does not derive, so the file is
// refused either way. VerA diagnoses the use itself (E0115).
//
// The expectation is the stable code and not the phase label ParseError, which
// any parse-phase failure satisfies: a typo'd keyword three lines down would
// pass the old form of this fixture while the macro rule went untested.
//
//! lrm 10.4
//! reject-only E0115
`include "disciplines.vams"
module ch10_undefined_macro(p, n);
  inout p, n; electrical p, n;
  analog I(p,n) <+ `MISSING*V(p,n);
endmodule
