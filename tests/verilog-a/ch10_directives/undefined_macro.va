// §10.4 hands `define and `undef to IEEE Std 1364. Its §19.3.2 says only that
// an undefined text macro "has no value"; no clause makes its use an error.
// VerA refuses the use (docs/specification/Vague_Decisions.md VD-126): expanding it to
// nothing would turn a typo into a silently different expression.
//
// The expectation is the stable code and not the phase label ParseError, which
// any parse-phase failure satisfies: a typo'd keyword three lines down would
// pass the old form of this fixture while the macro rule went untested.
//
//! lrm 10.4
//! reject-only E0115
`include "disciplines.vams"
module ch10_undefined_macro(p, n);
  inout p, n; electrical p, n;
  analog I(p,n) <+ `MISSING*V(p,n);
endmodule
