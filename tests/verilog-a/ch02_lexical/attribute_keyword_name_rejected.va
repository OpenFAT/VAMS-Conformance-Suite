// LRM 2.9 Syntax 2-4 and A.9.1: `attr_name ::= identifier`. A keyword is
// not an identifier (§2.8.2: keywords are "reserved identifiers"). IEEE
// 1364-2005 A.9.1 has the same production. The list also carries §2.9.2's
// standard `units`, which the LRM itself writes unescaped; a tool that refused
// that too would still refuse this file.
//
// The keyword `module` is the only change from the legal neighbour
// attribute_keyword_name_escaped.va, which writes it `\module ` and also uses
// `units`.
//! lrm 2.9
//! reject-only E0208
//! reject found keyword `module`: an attribute name is an identifier
//! neighbour attribute_keyword_name_escaped.va
`include "check.vh"
module attribute_keyword_name_rejected(p, n);
    inout p, n;
    electrical p, n;
    (* module = 1, units = "S" *) parameter real g = 2.0;
    analog I(p, n) <+ g * V(p, n);
endmodule
