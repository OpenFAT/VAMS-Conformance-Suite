// LRM 2.9 Syntax 2-4 and A.9.1: `attr_name ::= identifier`. §2.8.1 lets an
// escaped identifier spell a keyword (`\module ` is an identifier, not the
// keyword), and §2.9.2 writes its standard attribute `units` unescaped:
// `(* desc="...", units="..." *)`, even though annex B reserves `units`.
//
// Legal neighbour of attribute_keyword_name_rejected.va: the same attribute
// list with `module` escaped. HAND DERIVATION: the attributes carry no
// semantics VerA reads, so g keeps its default 2.0.
//! lrm 2.9
//! lrm 2.8.1
//! nowarn
//! checks 1
`include "check.vh"
module attribute_keyword_name_escaped(p, n);
    inout p, n;
    electrical p, n;
    (* \module = 1, units = "S" *) parameter real g = 2.0;
    analog begin
        `CHECKX("attributed parameter keeps its default", g, 2.0);
        I(p, n) <+ g * V(p, n);
    end
endmodule
