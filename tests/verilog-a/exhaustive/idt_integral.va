// §4.5.4 idt — the time integral, and the first fixture that needs the runner to
// commit accepted steps (`updateState`). Without that every point would read
// zero history and idt would answer `v*dt` forever.
//
// The kernel accumulates on ACCEPTED steps: `eval` returns `v*dt + acc` and
// `updateState` sets `acc += v*dt`. For a constant input that is exact, so the
// want at t = k*dt is ic + v*t with NO tolerance for discretization:
//
//   t=0     dt=0   -> the initial condition (§4.5.4: "When used in DC or IC
//                     analyses, idt() returns the initial condition (ic) if
//                     specified")
//   t=1ns          -> 5 + 2.0 * 1e-9
//   t=4ns          -> 5 + 2.0 * 4e-9
//
// Only the ic form is asserted. Without ic, Table 4-18's c is "the initial
// starting point as determined by the simulator", and §4.5.4: "If not
// specified, the idt operator must be contained within a negative feedback
// loop that forces its argument to zero. Otherwise the output of the idt
// operator is undefined." A constant integrand is no such loop.
//
//! param k = 2.0
//! bias V(n) = 0
//! bias V(p) = 1
//! time 0, 1n, 2n, 3n, 4n
//! analysis tran
//! print none
`include "check.vh"
module ex062_idt(p, n);
  inout p, n;
  electrical p, n;
  parameter real k = 1.0;
  analog begin
    // A constant integrand, so the exact integral is k*t and the accumulated
    // sum has to match it step for step.
    //
    // RELATIONAL, and it has to be: the want is a different number at every one
    // of the five time points, and a stateful operator shown a single point
    // says nothing at all. The closed form ic + k*t is §4.5.4's definition for
    // a constant integrand. The tolerance covers rounding only: adding 2e-9 to
    // 5.0 once per step may round each sum by half an ulp of 5 (4.4e-16), four
    // times over.
    `CHECKEQ("idt(k, ic) == ic + k*t", idt(k, 5.0), 5.0 + k * $abstime, 1e-14);
    // And the parameter the want is built from.
    `CHECK("k took the override", k, 2.0, 0.0);
    I(p, n) <+ 0.0;
  end
endmodule
