// §6.4.2: "The simulator shall consider only the ranges of the paramset's own
// parameters when choosing a paramset."
//
// The legal twin of paramset_module_range_is_not_a_selection_rule_rejected.va:
// the same two paramsets, with A's assignment 3.0, inside the module's
// r = 1.0 from (0:inf).
//   A: parameter l,             assigns .r = 3.0
//   B: parameters l and spare,  assigns .r = 2.0
// The instance overrides l = 1.5; both are applicable, and "the paramset with
// the fewest number of un-overridden parameters" picks A (0 against 1). So
// r = 3.0, and with V(p,n) = 0.75 - 0.25 = 0.5 the module conducts
// 0.5 / 3.0. Picking B instead reads r = 2.0.
//
//! lrm 6.4.2
//! lrm 6.4.2:7
//! lrm 6.4.2:12
//! bias V(p) = 0.75, V(n) = 0.25
//! checks 1
`include "check.vh"
module b4_pmrs_top(p, n);
  inout p, n; electrical p, n;
  b4_pmrs_ps #(.l(1.5)) u(p, n);
endmodule

paramset b4_pmrs_ps b4_pmrs_res;   // A: selected
  parameter real l = 1.0 from (0:inf);
  .r = 3.0;
endparamset

paramset b4_pmrs_ps b4_pmrs_res;   // B: loses the first tie-break
  parameter real l = 1.0 from (0:inf);
  parameter real spare = 1.0 from (0:inf);
  .r = 2.0;
endparamset

module b4_pmrs_res(a, b);
  inout a, b; electrical a, b;
  parameter real r = 1.0 from (0:inf);
  analog begin
    `CHECKX("the paramset with no un-overridden parameter is selected", r, 3.0);
    I(a, b) <+ V(a, b) / r;
  end
endmodule
