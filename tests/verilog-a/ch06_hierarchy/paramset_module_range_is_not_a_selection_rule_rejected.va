// §6.4.2: "If a paramset assigns a value to a module parameter and this value
// is outside the range specified for that module parameter, it shall be an
// error. The simulator shall consider only the ranges of the paramset's own
// parameters when choosing a paramset."
//
// Two paramsets named b4_pmrs_ps over one module, whose parameter
// r = 1.0 from (0:inf):
//   A: parameter l,             assigns .r = -1.0  (outside (0:inf))
//   B: parameters l and spare,  assigns .r =  2.0
// The instance overrides l = 1.5, inside both paramsets' range for l.
//
// BY HAND. Selection sees only l's and spare's ranges, which both paramsets
// satisfy, so both are applicable. The first tie-break, "the paramset with
// the fewest number of un-overridden parameters", picks A (0 against B's 1,
// spare). A then assigns -1.0 to r, outside the module's range: an error.
//
// A selector that also weighed the module's range would discard A, pick B and
// run cleanly with r = 2.0. That is what this file refuses. The neighbour
// differs only in A's value, 3.0, which is inside (0:inf): A is selected and
// the module reads r = 3.0.
//
//! lrm 6.4.2
//! lrm 6.4.2:11
//! lrm 6.4.2:12
//! reject paramset assigns r = -1.0, outside the module's range (VerA: E0361)
//! neighbour paramset_module_range_is_not_a_selection_rule.va
`include "disciplines.vams"
module b4_pmrs_top(p, n);
  inout p, n; electrical p, n;
  b4_pmrs_ps #(.l(1.5)) u(p, n);
endmodule

paramset b4_pmrs_ps b4_pmrs_res;   // A: selected, then out of the module's range
  parameter real l = 1.0 from (0:inf);
  .r = -1.0;
endparamset

paramset b4_pmrs_ps b4_pmrs_res;   // B: loses the first tie-break
  parameter real l = 1.0 from (0:inf);
  parameter real spare = 1.0 from (0:inf);
  .r = 2.0;
endparamset

module b4_pmrs_res(a, b);
  inout a, b; electrical a, b;
  parameter real r = 1.0 from (0:inf);
  analog I(a, b) <+ V(a, b) / r;
endmodule
