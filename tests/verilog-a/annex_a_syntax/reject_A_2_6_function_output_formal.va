// IEEE 1364-2005 A.2.6, which VAMS A.2.6 keeps for a function written without
// `analog`:
//
//     function_item_declaration ::= block_item_declaration
//             | { attribute_instance } tf_input_declaration ;
//
// There is no tf_output_declaration among a function's items (IEEE 1364-2005
// 10.4.1: a function returns its value through its name). `output out_arg;`
// belongs to a task or to an `analog function` (4.7.2.3). The legal neighbour
// is this module without that line.
//
// VerA refuses it with E0207 and a message naming A.2.6's rule; both are
// pinned. (The digital engine refuses the same text by 10.4.4, E1100:
// ieee1364 b_A_2_6_function_output_port_rejected.v.)
//
//! lrm A.2.6
//! lrm A.2.6:1000
//! reject-only E0207
//! reject-only gives a function `input` formals only
//! neighbour ../../verilog-ams/annex_a_syntax/function_input_formals_only.va
`include "check.vh"
module annex_a_function_inputs(p, n);
    inout p, n;
    electrical p, n;

    function real passive;
        input seed;
        output out_arg;           // illegal: a function has inputs only
        real seed;
        passive = seed;
    endfunction

    analog begin
        `CHECKX("the file declaring a digital function of inputs compiles and runs", V(p, n), 0.5);
        I(p, n) <+ V(p, n);
    end
endmodule
