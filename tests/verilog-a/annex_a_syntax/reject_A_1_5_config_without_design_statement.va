// A.1.5:
//
//     config_declaration ::=
//             config config_identifier ;
//                 design_statement
//                 {config_rule_statement}
//             endconfig
//
// design_statement is not optional: a configuration names its top-level
// design first. This one goes straight to a `default liblist` rule. Adding
// `design annex_a_cfg_top;` as the first item makes it legal, and VerA reads
// that form (probed; it warns W0253 that nothing binds through it).
//
// VerA reports E0207 "unexpected token: found `default`: a config_declaration
// begins with its `design` statement".
//
//! lrm A.1.5
//! lrm A.1.5:1000
//! reject-only E0207
//! reject begins with its `design` statement
//! neighbour ../../verilog-ams/annex_a_syntax/configuration_source_text.va
`include "disciplines.vams"
module annex_a_cfg_top(p, n);
  inout p, n;
  electrical p, n;
  analog I(p, n) <+ V(p, n);
endmodule

config annex_a_cfg;
  default liblist work;      // illegal: the design_statement is missing
endconfig
