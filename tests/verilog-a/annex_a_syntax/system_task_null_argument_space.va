// A.6.9's empty argument, observed. system_task_null_arguments.va writes
// `$strobe;` and `$strobe("a",,"b");`, but its one check reads the bias V(p):
// a display task in a device prints nothing a check can see, so it could only
// show that the next statement still ran. $swrite writes the same argument
// list into a string, which a check can read.
//
//     analog_system_task_enable ::= analog_system_task_identifier
//             [ ( [ analog_expression ] { , [ analog_expression ] } ) ] ;  // A.6.9
//
// §9.4.1: "Any null argument produces a single space character in the
// display. (A null argument is characterized by two adjacent commas (,,) in the
// argument list.)" §9.5.3: "The $swrite family of tasks is based on the $fwrite
// family of tasks and accepts the same type of arguments ... The first argument
// to $swrite shall be a string variable to which the resulting string shall be
// written". §9.5.2 makes $fwrite $write to a file, and $write is the display
// task without the newline. So each null argument in a $swrite list writes one
// space into the string, at its position.
//
// DERIVATION. No string argument below holds a `%` or a `\`, so each is written
// literally.
//
//   $swrite(s1, "a",,"b")       "a" + " " + "b"        = "a b"
//   $swrite(s2, "x",,,"y")      "x" + " " + " " + "y"  = "x  y"
//   $swrite(s3, ,"z")           " " + "z"              = " z"
//
// `$strobe;` takes the other A.6.9 bracket, the whole argument list omitted;
// it prints nothing a check can read, so it only has to compile. A tool that
// dropped a null argument writes "ab", "xy" and "z" (VerA did until
// 2026-10-08). No null argument here meets a `%` conversion: whether one can
// satisfy a conversion's "corresponding expression argument" is not stated.
//
//! lrm A.6.9
//! lrm 9.4.1
//! lrm 9.4.1:1001
//! lrm 9.5.3
//! lrm A.6.9:1000
//! bias V(p) = 0.5
//! checks 3
`include "check.vh"
module b8_system_task_null_argument_space(p);
  inout p; electrical p;
  string s1, s2, s3;
  analog begin
    $strobe;
    $swrite(s1, "a",,"b");
    $swrite(s2, "x",,,"y");
    $swrite(s3, ,"z");
    `CHECKI("one null argument writes one space: \"a b\"", (s1 == "a b"), 1);
    `CHECKI("two null arguments write two spaces: \"x  y\"", (s2 == "x  y"), 1);
    `CHECKI("a leading null argument writes a leading space: \" z\"", (s3 == " z"), 1);
    I(p) <+ V(p);
  end
endmodule
