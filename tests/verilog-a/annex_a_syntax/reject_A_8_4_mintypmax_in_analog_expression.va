// A.8.4 gives the parenthesised min:typ:max to the digital and constant
// primaries only:
//
//     primary          ::= ... | ( mintypmax_expression )
//     constant_primary ::= ... | ( constant_mintypmax_expression )
//     analog_primary   ::= ... | ( analog_expression )
//
// An analog block's assignment is `analog_variable_lvalue = analog_expression`
// (A.6.4), so `(1.0 : 2.0 : 3.0)` there derives from nothing: the second
// colon has no production that reads it. The same text as a parameter default
// is legal (A.2.4's param_assignment takes a constant_mintypmax_expression),
// which the neighbour reads: `parameter real a = 1.0 : 2.0 : 3.0;` gives 2.0.
//
// VerA refuses it with E0295 at the first `:` inside the parentheses; the code
// is pinned.
//
//! lrm A.8.4
//! lrm A.8.4:1000
//! reject-only E0295
//! neighbour ../../verilog-ams/annex_a_syntax/mintypmax_constant_takes_typical.va
`include "disciplines.vams"
module annex_a_mintypmax_in_analog(p, n);
    inout p, n;
    electrical p, n;
    real x;

    analog begin
        x = (1.0 : 2.0 : 3.0);     // illegal: analog_primary is ( analog_expression )
        I(p, n) <+ x * V(p, n);
    end
endmodule
