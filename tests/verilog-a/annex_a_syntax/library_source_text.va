// A.1.1 Library source text:
//
//     library_text ::= { library_description }
//     library_description ::=
//             library_declaration
//             | include_statement
//             | config_declaration
//     library_declaration ::=
//             library library_identifier file_path_spec [ { , file_path_spec } ]
//             [ -incdir file_path_spec { , file_path_spec } ] ;
//
// Annex A's preamble: "The syntax of Verilog-AMS HDL source is derived from the
// starting symbol source_text. The syntax of a library map file is derived from
// the starting symbol library_text." A.1.2's `description` list (module, udp,
// config, paramset, nature, discipline, connectrules) has no
// `library_description`, and A.1.1 admits no module. So this file, a
// `library_declaration` followed by a module, derives from NEITHER start
// symbol, and the conforming answer to it as a `.va` is a refusal.
//
// This row used to be an xfail wanting the file to compile and run; that want
// was one no conforming tool could meet (docs/conformance-annex-a-review.md at 8b1514d4,
// A-EVID-001). The positive obligation, a library map file read as its own
// input and binding a separate design (A-EVID-001), is not claimed here. What is left here is the refusal, pinned to
// its code: E0232 "library map text in a source file".
//
//! lrm A.1.1
//! lrm A.1.2
//! lrm A
//! lrm A:1000
//! lrm A.1.2:1000
//! reject-only E0232
//! lrm A:1001
//! neighbour ../../verilog-ams/annex_a_syntax/configuration_source_text.va
`include "check.vh"
library annex_a_lib "." ;
module annex_a_library_host(p, n);
    inout p, n;
    electrical p, n;
    analog I(p, n) <+ V(p, n);
endmodule
