// §9.17.2: "For a given time step, the simulator shall ensure that the next
// time step taken is no larger than the smallest $bound_step() argument
// currently active." Several calls may be active in one evaluation, and the
// bound is the smallest argument of the calls that ran.
//
// By hand: at V(p,n) = 1 the three calls 3 ns, 1 ns (its guard is true) and
// 2 ns all run, so the bound is 1 ns; at V(p,n) = 0 the guarded call does not
// run and the bound is min(3 ns, 2 ns) = 2 ns. A device has no transcript of
// its step bound, so bound_step_smallest_host.zig (under `zig build test`)
// runs this device's updateState at both biases and reads
// `Instance.bound_step`: 1e-9, then 2e-9. The transcript below checks the
// branch current only. The invalid input, "The expression argument shall be
// non-negative", is bound_step_negative_rejected.va.
//! lrm 9.17.2
//! lrm 9.17.2:3
//! analysis tran
//! time 0, 1n
//! bias V(p) = 1, V(n) = 0
//! checks 2
`include "check.vh"
module bound_step_smallest_active_wins(p, n);
  inout p, n; electrical p, n;
  analog begin
    $bound_step(3n);
    if (V(p, n) > 0.5) $bound_step(1n);
    $bound_step(2n);
    `CHECKX("the branch carries V(p,n)/1k", V(p, n) / 1k, 1e-3);
    I(p, n) <+ V(p, n) / 1k;
  end
endmodule
