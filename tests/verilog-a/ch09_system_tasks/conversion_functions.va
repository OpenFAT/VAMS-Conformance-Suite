// §9.11 conversion system functions in the analog context. The extension is
// FOUR names in two pairs: "Verilog AMS HDL extends the conversion functions
// defined in IEEE Std 1364 Verilog so that $bitstoreal and $realtobits, $rtoi
// and $itor can be used in the analog context." Table 9-8 (printed p.221,
// physical p.234) says the same row by row — `$bitstoreal Yes Yes`,
// `$realtobits Yes Yes`, `$rtoi Yes Yes`, `$itor Yes Yes`. The only analog "No"
// cells in the family are `$signed` and `$unsigned`, pinned as rejects in
// 134/135 and not exercised here. The current audit observes runtime $rtoi and
// $itor behavior in conversion_truncation_signed.va; their parameter-
// default path remains broken in conversion_constant_expressions.va.
// The former blanket "unimplemented" claim is superseded by those distinct
// observations, not by compile acceptance alone.
//
// $realtobits yields the 64-bit IEEE-754 PATTERN of the real and $bitstoreal
// maps that pattern back, so the pair is the identity on any real: bit-exact,
// hence CHECKX rather than a tolerance. The bias is 3.7 because it is not
// representable in binary — an implementation that routed the pattern through
// a narrower carrier, or truncated it, loses the mantissa and fails on the .7
// where it would survive an integral bias.
//
//! lrm 9.11
//! lrm 9.11:1000
//! fd-exempt §9.11: $realtobits's result is an integer bit pattern with no derivative, so the Jacobian of the round trip is 0 where a difference sees the identity
//! bias V(p) = 3.7
`include "check.vh"
module ch09_conversion_functions(p, n);
  inout p, n; electrical p, n;
  real x;
  analog begin
    `CHECKX("§9.11 $bitstoreal of $realtobits is the identity on 3.7",
            $bitstoreal($realtobits(V(p,n))), 3.7);
    x = $bitstoreal($realtobits(V(p,n)));
    `CHECKX("and the round trip survives being stored in a real", x, 3.7);
    I(p,n) <+ x;
  end
endmodule
