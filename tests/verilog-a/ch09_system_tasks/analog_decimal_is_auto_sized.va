// §9.1: "Verilog-AMS HDL is a superset of IEEE Std 1364 Verilog and hence all
// the system tasks in IEEE Std 1364 Verilog are supported." §9.4.1:
// "Verilog-AMS extends the display tasks so that they can be used in the
// analog context", and §9.4.3 Table 9-22 says only that %d is "Display in
// decimal format". The analog context therefore keeps IEEE 1364-2005
// §17.1.1.3's automatic sizing, as display_radix_of_integer_is_32_bits.va
// already reads it for %h: "When displaying decimal values, leading zeros are
// suppressed and replaced by spaces", the field being as wide as the largest
// value the expression can take; a zero width (%0d) overrides it (#61).
//
// HAND DERIVATION. A signed n-bit field holds -2^(n-1): its digits plus a
// sign column. n = 32 (§3.2's `integer`; an unsized literal, IEEE 1364
// §3.5.1): 2147483648 is 10 digits, 11 columns. A comparison is one bit,
// unsigned (IEEE 1364 Table 5-22): one column. (%d of a real is not asserted:
// how wide the integer a real converts to is, and so its field, is not
// stated.)
//   [%d]  of integer k = -42       "-42" in 11 columns: 8 spaces
//   [%0d] of k                     no automatic size: "[-42]"
//   bare k, §9.4.3's default       %d's field: 8 spaces, "-42"
//   [%d]  of integer parameter 7   10 spaces, "7"
//   [%d]  of unsized literal 5     10 spaces, "5"
//   [%d]  of (k < 0)               1, one column: "[1]"
//   [%h]  of k                     32-bit pattern, 8 digits: ffffffd6
// The same statement in the digital context prints the same text (the
// digital engine's `kernels/fmt.zig` `autoWidth`; iverilog agrees for the
// integer). There is no invalid input: %d takes any numeric operand.
//! lrm 9.4.3
//! lrm 9.4.1
//! inherited IEEE 1364-2005 17.1.1.3
//! print none
//! checks 7
`include "check.vh"
module analog_decimal_is_auto_sized(p, n);
    inout p, n; electrical p, n;
    parameter integer np = 7;
    integer k; string t;
    analog begin
        k = -42;
        $sformat(t, "[%d]", k);
        `CHECKI("%d of a 32-bit integer is 11 columns", t == "[        -42]", 1);
        $sformat(t, "[%0d]", k);
        `CHECKI("%0d of the same integer is its digits alone", t == "[-42]", 1);
        $swrite(t, "[", k, "]");
        `CHECKI("a bare integer takes %d's field", t == "[        -42]", 1);
        $sformat(t, "[%d]", np);
        `CHECKI("%d of an integer parameter is 11 columns", t == "[          7]", 1);
        $sformat(t, "[%d]", 5);
        `CHECKI("%d of an unsized literal is 11 columns", t == "[          5]", 1);
        $sformat(t, "[%d]", k < 0);
        `CHECKI("%d of a comparison is one column", t == "[1]", 1);
        $sformat(t, "[%h]", k);
        `CHECKI("%h of the integer is its 8-digit pattern", t == "[ffffffd6]", 1);
        I(p, n) <+ V(p, n);
    end
endmodule
