// §9.7.3: "Non-fatal system severity tasks ($error, $warning, $info) called
// during a rejected iteration shall have no effect."
//
// THE REJECTED ITERATION is finish_in_rejected_iteration_has_no_effect.va's:
// §9.17.3 calls $discontinuity(-1) "In order to prevent convergence", so an
// iteration that calls it cannot be accepted. The call and the three tasks sit
// in one guarded statement, V(p,n) < 0.5e-10, which holds on iterates short of
// the solution V(p,n) = 1e-10 and not at it. No iteration number is assumed.
//
// THE OBSERVABLE. A severity task's effect is its message. Each message
// carries "ok=0", and the harness fails a run whose output has a line saying
// ok=0, so any one of the three printing fails this file. (A tool that prints
// them only to stderr hides them from that rule; the check below still holds
// it to reaching the accepted solution.) A tool whose first iterate is
// already the solution never takes the guard and passes trivially.
//
//! lrm 9.7.3
//! lrm 9.7.3:6
//! lrm 9.17.3
//! solve
//! bias V(n) = 0
//! checks 1
`include "check.vh"
module b6_severity_in_rejected_iteration_has_no_effect(p, n);
  inout p, n; electrical p, n;
  analog begin
    if (V(p, n) < 0.5e-10) begin
      $discontinuity(-1);
      $error("ok=0 $error in a rejected iteration was reported");
      $warning("ok=0 $warning in a rejected iteration was reported");
      $info("ok=0 $info in a rejected iteration was reported");
    end
    I(p, n) <+ V(p, n) - 1e-10;
    `CHECK("the run reached the accepted solution", V(p, n), 1e-10, 1e-18);
  end
endmodule
