// §9.15 `$simparam(param_name [, expression])`: "If param_name is not known,
// and the optional expression is not supplied, then an error is generated. If
// the optional expression is supplied, its value is returned if param_name is
// not known and no error is generated."
//
// So the one value this function pins without consulting some PARTICULAR
// simulator's parameter set is the fallback for a name no simulator can know.
// `"conform_no_such_simparam"` is not in Table 9-27 and is not a plausible vendor
// extension, so the LRM requires the second argument back — unchanged, and as
// a real, hence `CHECKX` rather than a tolerance.
//
// The two calls in the contribution below are deliberately NOT checked:
// Table 9-27 names "gmin" and "scale" but fixes neither's value, so any digits
// written for them would be a recording of this engine's own defaults.
//
// Both of them carry a fallback anyway, and that is not decoration. Table 9-27
// is prefaced "to access commonly-known simulation parameters, IF THEY SUPPORT
// THE PARAMETER", and §9.15 makes the no-fallback form on a name the tool does
// not know an error — which is the entire content of 147. `$simparam("scale")`
// bare would therefore make this RUN fixture illegal on any conforming compiler
// that does not implement "scale", against a rule the fixture is not testing.
// `$simparam("scale", 1.0)` is legal for every tool, known name or not.
//
// The second sentence quoted above — the unknown name with NO fallback, which
// is an error — is simparam_unknown_no_fallback_rejected.va.
//
//! lrm 9.15
//! lrm 9.15:1003
`include "check.vh"
module ch09_simparam(p, n);
  inout p, n; electrical p, n;
  analog begin
    `CHECKX("an unknown $simparam returns its fallback expression verbatim",
            $simparam("conform_no_such_simparam", 2.5), 2.5);
    I(p,n) <+ $simparam("gmin", 1e-12) + $simparam("scale", 1.0) + 0.0*V(p,n);
  end
endmodule
