// §9.21.1: "The state of the data source is captured on the first call to the
// table model function. Any change after this point is ignored."
//
// table_snapshot.va pins the capture in one module. This file pins it per
// INSTANCE: two instances of one leaf, whose array data source depends on the
// instance parameter k, each capture their own data on their own first call.
//
// DERIVATION. In each leaf the data source is the two-point line
//   xs = {0, 1},  ys = {k*(t+1), 2*k*(t+1)}   (t = $abstime)
// so on the first call, at t = 0, it is {k, 2k}, and the table at x = 0.5
// interpolates (§9.21.4, linear default) to 1.5k, so v/k = 1.5 in both:
//   la (k = 1): 1.5     lb (k = 2): 3.0
// At t = 1 and t = 2 the arrays are rewritten ({2k, 4k}, then {3k, 6k}), and
// "any change after this point is ignored", so both values hold. A tool that
// re-read the arrays would give 3.0/6.0 at t = 1; one that kept a single
// capture per call site (shared by the instances) would give lb v = 1.5,
// v/k = 0.75.
//
//! lrm 9.21.1
//! lrm 9.21.1:1001
//! analysis tran
//! time 0, 1, 2
//! checks 6
`include "check.vh"
module a05_14_leaf(p);
  inout p; electrical p;
  parameter real k = 1.0;
  real xs[0:1], ys[0:1], v;
  analog begin
    xs[0] = 0.0; xs[1] = 1.0;
    ys[0] = k*($abstime + 1.0); ys[1] = 2.0*k*($abstime + 1.0);
    v = $table_model(0.5, xs, ys);
    `CHECK("each instance keeps the data it captured on its first call (v/k)", v / k, 1.5, 1e-12);
    I(p) <+ V(p) - v;
  end
endmodule
module a05_14_table_snapshot_per_instance(a, b);
  inout a, b; electrical a, b;
  a05_14_leaf #(.k(1.0)) la(a);
  a05_14_leaf #(.k(2.0)) lb(b);
endmodule
