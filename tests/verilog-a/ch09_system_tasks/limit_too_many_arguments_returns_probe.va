// §9.17.3, Syntax 9-12: `$limit ( access_function_reference , string,
// arg_list )`. The arg_list is the built-in's own; the clause fixes no length.
// "In all cases, the simulator is responsible for determining if limiting
// should be applied and what the return value is on a given iteration", but
// "On any iteration where the output value is not the same as the value of
// the access function (within appropriate tolerances), the simulator is
// prevented from terminating the iteration." So however a tool reads the
// extra arguments, the converged return is the probe. (VerA declines the site
// with W0853 and returns the probe unchanged.)
//
// Two 100 ohm resistors divide V(p) = 1 V, so V(a) = 0.5 V, independent of any
// limiting; the returned value is used in the contribution, so a return other
// than the probe would move the root.
//
//! lrm 9.17.3
//! lrm 9.17.3:2
//! solve
//! bias V(p) = 1, V(n) = 0
`include "check.vh"
module limit_too_many_arguments_returns_probe(p, n);
  inout p, n; electrical p, n, a;
  real v;
  analog begin
    v = $limit(V(a,n), "steplim", 0.1, 1, 0.5, 7);
    I(p,a) <+ V(p,a) / 100.0;
    I(a,n) <+ v / 100.0;
    `CHECKR("the converged $limit is the probe", v, 0.5, 1e-4);
  end
endmodule
