// §9.17.3: "When the second argument is a string, it refers to a built-in
// function of the simulator. ... If the string refers to an unknown or
// unsupported function, the simulator is responsible for determining the
// appropriate limiting algorithm, just as if no string had been supplied."
// So "steplim" (a step bound, in VerA) may or may not be known; either way
// "On any iteration where the output value is not the same as the value of
// the access function (within appropriate tolerances), the simulator is
// prevented from terminating the iteration", so the converged $limit is the
// probe's value, and the checks assert only that.
//
// The circuit is limit_pnjlim_internal_node_honoured.va's, so the root is
// its: the KCL at `a`, (0.7 - Va) / 100 = 1e-14 * (exp(Va / 0.025) - 1), one
// root, Va = 0.625763159 by bisection over [0, 0.7]. A 0.1 V step bound only
// changes the path Newton takes to it. The band is the solver's convergence
// tolerance, relative 1e-4, as in 226.
//
//! lrm 9.17.3
//! solve
//! bias V(p) = 0.7, V(n) = 0
`include "check.vh"
module limit_steplim_internal_node_honoured(p, n);
  inout p, n; electrical p, n, a;
  real vd;
  analog begin
    vd = $limit(V(a,n), "steplim", 0.1);
    I(p,a) <+ V(p,a) / 100.0;
    I(a,n) <+ 1e-14 * (exp(vd / 0.025) - 1.0);
    `CHECKR("the junction settles at the KCL root", V(a,n), 0.625763159, 1e-4);
    `CHECKR("and the converged $limit returns it", vd, 0.625763159, 1e-4);
  end
endmodule
