// §9.7.1: "$finish called during a rejected iteration shall have no effect."
//
// THE REJECTED ITERATION. §9.17.3: $discontinuity(-1) is called "In order to
// prevent convergence", so an iteration that calls it cannot be the one the
// solver accepts: it is a rejected iteration. Here the call and the $finish
// sit in the same guarded statement, so whichever iterations the guard holds
// on, each one that runs the $finish is rejected. No iteration number is
// assumed.
//
// THE CIRCUIT. `//! solve` frees p; the branch is I = V(p,n) - 1e-10, linear,
// so the solution is V(p,n) = 1e-10. The guard V(p,n) < 0.5e-10 holds on any
// iterate short of the solution (Newton from 0 V starts there) and not at it,
// so the vetoed iterates are exactly the ones the solver passes through, and
// the solution itself is accepted.
//
// THE OBSERVABLE. Had a $finish in a vetoed iterate taken effect, the run
// would end before the accepted solution existed and the check below would
// never print (`//! checks 1` then fails). A tool whose first iterate is
// already the solution never takes the guard and passes trivially.
//
//! lrm 9.7.1
//! lrm 9.7.1:3
//! lrm 9.17.3
//! solve
//! bias V(n) = 0
//! checks 1
`include "check.vh"
module b6_finish_in_rejected_iteration_has_no_effect(p, n);
  inout p, n; electrical p, n;
  analog begin
    if (V(p, n) < 0.5e-10) begin
      $discontinuity(-1);
      $finish(1);
    end
    I(p, n) <+ V(p, n) - 1e-10;
    `CHECK("the run reached the accepted solution", V(p, n), 1e-10, 1e-18);
  end
endmodule
