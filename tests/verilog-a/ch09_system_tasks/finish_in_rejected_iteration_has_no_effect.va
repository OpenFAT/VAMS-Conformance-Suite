// §9.7.1: "$finish called during a rejected iteration shall have no effect."
//
// THE REJECTED ITERATION. §9.17.3: $discontinuity(-1) is called "In order to
// prevent convergence", so an iteration that calls it cannot be the one the
// solver accepts: it is a rejected iteration. Here the call and the $finish
// sit in the same guarded statement, so whichever iterations the guard holds
// on, each one that runs the $finish is rejected. No iteration number is
// assumed.
//
// THE CIRCUIT. `//! solve` frees p; the branch is I = exp(V(p,n)) - 2, so the
// solution is V(p,n) = ln 2. The guard |V(p,n) - ln 2| > 1e-6 holds on every
// iterate short of the solution and not at it. The branch is nonlinear, so
// no solver reaches ln 2 without evaluating the block at some other point
// first, and that evaluation takes the guard. The veto is what keeps the test
// correct on any convergence criterion: without it a solver with a loose
// tolerance could accept an iterate the guard holds on, where $finish is
// legal. The accepted iterate is one the guard does not hold on, so it is
// within 1e-6 of ln 2: the check's tolerance.
//
// THE OBSERVABLE. Had a $finish in a vetoed iterate taken effect, the run
// would end before the accepted solution existed and the check below would
// never print (`//! checks 1` then fails). A tool that runs a block's tasks
// only at accepted solutions passes without ever running the guarded
// statement in an iterate; that is the passing kind, not a blind spot. The
// guarded $debug, which §9.4.1 says "displays its arguments for each
// iteration of the analog solver", logs each vetoed iterate, so a transcript
// shows the guard was taken.
//
//! lrm 9.7.1
//! lrm 9.7.1:3
//! lrm 9.17.3
//! solve
//! bias V(n) = 0
//! checks 1
`include "check.vh"
module b6_finish_in_rejected_iteration_has_no_effect(p, n);
  inout p, n; electrical p, n;
  analog begin
    if (abs(V(p, n) - ln(2.0)) > 1e-6) begin
      $discontinuity(-1);
      $debug("guard held on a vetoed iterate at V(p,n) = %g", V(p, n));
      $finish(1);
    end
    I(p, n) <+ exp(V(p, n)) - 2.0;
    `CHECK("the run reached the accepted solution", V(p, n), ln(2.0), 1e-6);
  end
endmodule
