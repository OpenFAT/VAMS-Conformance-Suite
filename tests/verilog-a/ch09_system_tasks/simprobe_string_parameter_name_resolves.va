// §9.16: "The arguments inst_name and param_name are string values, either a
// string literal, string parameter, or a string variable." Here both names are
// string parameters; simprobe_runtime_name_resolves.va holds the instance name
// in a string variable instead.
//
// §9.16: "$simprobe() queries the simulator for an output variable named
// param_name in a sibling instance called inst_name", and "the simulator will
// look for an instance called inst_name in the parent of the current
// instance". u_m and u_a are siblings under the top. g is u_a's output
// variable (§3.2.1: "Module scope variables with a description or units
// attribute, or both, shall be known as output variables"), assigned u_a's
// gain, overridden to 3.0. So $simprobe(inst, par) with inst = "u_a" and
// par = "g" is 3.0. The fallback -1.0 is chosen so that a probe that fails to
// resolve cannot pass.
//
//! lrm 9.16
//! lrm 9.16:1001
//! lrm 3.2.1
//! bias V(p) = 0.75, V(n) = 0.25
//! checks 1
`include "check.vh"
module simprobe_string_parameter_name_resolves(p, n);
  inout p, n;
  electrical p, n;
  simprobe_spn_dev #(.gain(3.0)) u_a(p, n);
  simprobe_spn_mon u_m(p, n);
endmodule

module simprobe_spn_dev(c, d);
  inout c, d;
  electrical c, d;
  parameter real gain = 1.0;
  (* desc = "gain" *) real g;
  analog begin
    g = gain;
    I(c, d) <+ gain * V(c, d);
  end
endmodule

module simprobe_spn_mon(c, d);
  inout c, d;
  electrical c, d;
  parameter string inst = "u_a";
  parameter string par = "g";
  real got;
  analog begin
    got = $simprobe(inst, par, -1.0);
    `CHECKX("string parameters name the sibling's output variable", got, 3.0);
    I(c, d) <+ 0.0 * V(c, d);
  end
endmodule
