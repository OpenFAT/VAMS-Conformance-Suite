// §9.16: "The arguments inst_name and param_name are string values, either a
// string literal, string parameter, or a string variable." The names are in
// string parameters here; simprobe_runtime_name_resolves.va holds them in
// string variables.
//
// The monitor u_m is a sibling of u_a under the top, and u_a's gain is
// overridden to 3.0, so $simprobe(inst, par) with inst = "u_a" and
// par = "gain" is 3.0 by "the simulator will look for an instance called
// inst_name in the parent of the current instance". The fallback -1.0 is
// chosen so that a probe that fails to resolve cannot pass.
//
//! lrm 9.16
//! lrm 9.16:1001
//! bias V(p) = 0.75, V(n) = 0.25
//! checks 1
`include "check.vh"
module simprobe_string_parameter_name_resolves(p, n);
  inout p, n;
  electrical p, n;
  simprobe_spn_dev #(.gain(3.0)) u_a(p, n);
  simprobe_spn_mon u_m(p, n);
endmodule

module simprobe_spn_dev(c, d);
  inout c, d;
  electrical c, d;
  parameter real gain = 1.0;
  analog I(c, d) <+ gain * V(c, d);
endmodule

module simprobe_spn_mon(c, d);
  inout c, d;
  electrical c, d;
  parameter string inst = "u_a";
  parameter string par = "gain";
  real got;
  analog begin
    got = $simprobe(inst, par, -1.0);
    `CHECKX("string parameters name the sibling's parameter", got, 3.0);
    I(c, d) <+ 0.0 * V(c, d);
  end
endmodule
