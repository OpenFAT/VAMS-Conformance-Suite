// §9.15 Table 9-28 "analysis_name" through the host's string table (ESPice
// #10), a branch it drives, and the §4.6.3 stimuli it selects.
//
// Table 9-28: "analysis_name" is "The name of the current analysis (e.g.,
// tran1, mydc)" and "analysis_type" is "The type of the current analysis
// (e.g., dc, tran, ac)": two different strings. §4.6.3: "The AC stimulus
// function returns zero (0) during large-signal analyses (such as DC and
// transient) as well as on all small-signal analyses using names which do not
// match analysis_name. The name of a small-signal analysis is implementation
// dependent, although the expected name (of the equivalent of a SPICE AC
// analysis) is "ac", which is the default value of analysis_name."
//
// This testbench runs one `.ac` analysis and labels it "myac" (the second
// word of `//! analysis`), publishing the label the way a GPU host can: the
// bytes in `contract.host_strings`, the `Model` row only the index
// (`Model.analysis_name_idx__`); the `Instance.analysis_name` slice stays "".
//
// Which name §4.6.3 matches against is "implementation dependent": the
// label "myac", the kind "ac", or both. So ac_stim() and ac_stim("myac") are
// not asserted; a name that is neither is zero under every reading. With mag
// as written:
//     ac_stim("other", 2.5)   neither "myac" nor "ac"                     0.0
//     ac_stim("noise", 2.5)   neither                                     0.0
// The branch: g = 1/R = 1e-3 S when the label read back is "myac", else 0,
// and I(p,n) <+ g·V(p,n) + ac_stim("myac", 2.5); its conductance dI/dV(p) is
// g, the stimulus being independent of V (§4.5.14).
//
// Wrong implementations: a device reading only VerA's Instance slice reads ""
// (fails the first three checks); one that answers analysis_type for
// analysis_name reads "ac".
//
// No invalid form beside it: an analysis name that is not a string literal is
// E0521 (ac_stim_name_not_literal_rejected.va).
//
//! lrm 9.15
//! lrm 9.15:4
//! lrm 4.6.3
//! lrm 4.6.3:1
//! analysis ac myac
//! bias V(p) = 0.5
//! bias V(n) = 0.0
`include "check.vh"
module simparam_str_analysis_name_host_table(p, n);
    inout p, n;
    electrical p, n;
    parameter real R = 1000.0 from (0:inf);
    string an;
    real g;

    analog begin
        an = $simparam$str("analysis_name");
        `CHECKI("Table 9-28 analysis_name is the host's label", an == "myac", 1);
        g = (an == "myac") ? 1.0 / R : 0.0;
        `CHECKX("the label reached the device, so the branch conducts", g, 1.0e-3);
        `CHECK("the branch's conductance is that g", ddx(g * V(p, n) + ac_stim("myac", 2.5), V(p)), 1.0e-3, 1e-18);
        `CHECKX("a name that is neither is not", ac_stim("other", 2.5), 0.0);
        `CHECKX("\"noise\" is another kind", ac_stim("noise", 2.5), 0.0);
        I(p, n) <+ g * V(p, n) + ac_stim("myac", 2.5);
    end
endmodule
