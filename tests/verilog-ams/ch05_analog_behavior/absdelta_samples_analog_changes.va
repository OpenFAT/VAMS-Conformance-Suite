// §5.10.3.4 permits absdelta in a discrete initial/always block; §7.3.5
// describes analog events in that discrete context. §5.10.3.4: "If delta is
// set to zero, an event is generated every timestep the expression value
// changes with zero tolerances", and an event is generated "During
// initialization".
//
// DERIVATION: the input rises by 0.5 V per listed 5 ns interval, from 0 V
// to 2 V, and the analog block runs at each listed point, so the delta=0
// sampler takes an event at each of them. Whether the analog block at a
// point reads that point's digital update or the previous one is §8's
// synchronization, so the check allows one interval of lag: 0.5 V, bound
// at 0.6 V. A sampler stuck at its initial zero fails by 10 ns.
//
// A positive delta is not checked here: its event time depends on time_tol
// and expr_tol, which "If the tolerances are not specified, then the tool
// (e.g., the simulator) sets them", so no bound on the lag follows.
//
//! lrm 5.10.3.4
//! lrm 7.3.5
//! lrm 7.3.5:1000
//! analysis tran
//! time 0, 5n, 10n, 15n, 20n
//! wave V(e_in) = 0.0, 0.5, 1.0, 1.5, 2.0
//! lrm 5.10.3.4:1
//! lrm 5.10.3.4:1001
//! lrm 5.10.3.4:1003
`timescale 1ns/100ps
`include "check.vh"
module ch5_absdelta_samples(e_in, p);
  inout e_in, p;
  electrical e_in, p;
  real tracked;

  always @(absdelta(V(e_in), 0.0))
    tracked = V(e_in);

  analog begin
    // A bound, not a value with a band: a CHECKI of its inequality, so a
    // perturbed run has a want to move (`benchmark -- --perturb`).
    `CHECKI("absdelta with delta = 0 samples every timestep, so the copy follows the signal",
            abs(tracked - $abstime * 1e8) <= 0.6, 1);
    I(p) <+ 1m * tracked;
  end
endmodule
