// The two type lists of A.2.2.1, and the declarations of A.2.1.3 that use them:
//
//     net_type ::=                                                        // A.2.2.1
//             supply0 | supply1 | tri | triand | trior | tri0 | tri1
//             | uwire | wire | wand | wor                                 // eleven spellings
//     real_type ::= real_identifier { dimension } [ = constant_assignment_pattern ]
//                 | real_identifier = constant_expression
//     variable_type ::= variable_identifier { dimension } [ = constant_assignment_pattern ]
//                     | variable_identifier = constant_expression
//     net_declaration ::= net_type [ discipline_identifier ] [ signed ]
//             [ delay3 ] list_of_net_identifiers ;                     // A.2.1.3
//     reg_declaration ::= reg [ discipline_identifier ] [ signed ] [ range ]
//             list_of_variable_identifiers ;
//     time_declaration ::= time list_of_variable_identifiers ;
//     realtime_declaration ::= realtime list_of_real_identifiers ;
//
// THE NET_TYPE LIST IS A SPELLING LIST, so the only claim that can be made
// about it is that all eleven spellings are accepted as net types. All eleven
// are declared below. That is a parse-level claim and this directory does not
// usually credit one, which is why the file also asserts values: the five
// variable declarations carry initializers (A.2.2.1's `variable_type` second
// arm — the `= constant_expression` one), and each one is read back.
//
// THE `reg` IS READ, NOT ASSIGNED, IN THE ANALOG BLOCK. §5.7: the left-hand
// side of an analog procedural assignment "shall be scalar, either an
// integer, real, or string identifier or an element of an integer, real or
// string array", and §7.3: "Write operations of nets and variables are only
// allowed from the context of their domain." Its initializer sets it; §7.3.1
// Table 7-1 reads its 8 bits as an integer.
//
// WHAT IS DELIBERATELY NOT DONE. The nets are declared and NOT read: reading a
// digital net inside an `analog` block is E0315 ("net must be read through an
// access function") or E0337 ("net has no declared discipline") here, and
// whether that is a subset boundary or a rule is a different question from
// A.2.2.1's. Nothing in this file touches it.
//
// THE INITIALIZERS ARE ALL EXACT IN BINARY — 7, 3, 2.5 = 5/2, 1.5 = 3/2, 0x5a — so
// `CHECKI` and `CHECKX` need no tolerance and a compiler that folded, truncated
// or re-ordered the initializers reads a different double. `wire [3:0] wbus =
// 4'h5;` is A.2.4's `net_decl_assignment` and is left unread for the reason
// above.
//
// `wire signed [3:0] wsigned;` IS NOT HERE, and its absence is a known gap
// rather than an oversight: A.2.1.3's third and fourth `net_declaration` arms
// carry `[ signed ]`, and VerA refuses the spelling with E0208 "expected an
// identifier: found `signed`". The same holds for `wreal`, A.2.1.3's
// `wreal [ discipline_identifier ] [ range ]` arms, refused with E0205
// "unsupported module item: found wreal" — `wreal` is one of the nine keywords
// Annex C.16 lists as unused by Verilog-A, which does not exempt a full-AMS
// implementation from it (§1.1, and the completion rules this directory is
// written under). Neither is spelled below, because this file has to compile;
// both are recorded here so the pair of refusals is not mistaken for coverage.
//
// `A.2.2` (Declaration data types) is cited as well: it is the heading over the
// subclause this file exercises and states no production of its own, so this
// file is evidence for it on the same positive side.
//
//! lrm A.2.2
//! lrm A.2.2.1
//! lrm A.2.1.3
//! lrm A.2.4
//! lrm A.2.1.3:1000
//! lrm A.2.2.1:1000
//! lrm 5.7
//! lrm 7.3.1
//! bias V(p) = 0.75, V(n) = 0.25
`include "check.vh"
module annex_a_types(p, n);
    inout p, n;
    electrical p, n;

    supply0 s0;
    supply1 s1;
    tri t;
    triand ta;
    trior t_o;
    tri0 t0;
    tri1 t1;
    uwire uw;
    wire w;
    wand wa;
    wor wo;
    wire [3:0] wbus = 4'h5;

    time tv = 3;
    realtime rtv = 2.5;
    real dv = 1.5;
    integer iv = 7;
    reg [7:0] rbus = 8'h5a;

    analog begin
        `CHECKX("the file declaring all eleven net_type spellings compiles and runs",
                V(p, n), 0.5);
        `CHECKI("a `time` variable keeps the integer it was initialized to", tv, 3);
        `CHECKX("a `realtime` variable is a real", rtv, 2.5);
        `CHECKX("a `real` variable", dv, 1.5);
        `CHECKI("an `integer` variable", iv, 7);
        `CHECKI("a vector `reg` keeps its initializer, read as an integer", rbus, 90);
        I(p, n) <+ V(p, n);
    end
endmodule
