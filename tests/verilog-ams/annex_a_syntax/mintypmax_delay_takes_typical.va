// A.8.3's min:typ:max expression as a delay in a .va, observed: the two
// digital delay productions a Verilog-AMS module's discrete half writes.
//
//     delay3 ::= # delay_value | # ( mintypmax_expression
//             [ , mintypmax_expression [ , mintypmax_expression ] ] )  // A.2.2.3
//     continuous_assign ::= assign [ drive_strength ] [ delay3 ]
//             list_of_net_assignments ;                                // A.6.1
//     delay_control ::= # delay_value | # ( mintypmax_expression )     // A.6.5
//     mintypmax_expression ::= expression
//             | expression : expression : expression                  // A.8.3
//
// IEEE 1364-2005 §5.3: "Verilog HDL models typically specify three values for
// delay expressions. The three values allow a design to be tested with
// minimum, typical, or maximum delay values." Which one a run uses is the
// tool's, so each check holds for any of 2, 4 or 6.
//
// DERIVATION (`timescale 1ns/1ns):
//   y = 0 at 0, then `#(2:4:6) y = 1;`             y rises at 2, 4 or 6
//   a = 0 at 0, a = 1 at 10; `assign #(2:4:6) w = a;` w is 0 from 2, 4 or 6
//                                                  and 1 from 12, 14 or 16
// Checks, from a second initial block, as $strobe (end of the time step):
//   t=1   y = 0                  (no member has elapsed)
//   t=7   {y, w} = 2'b10 = 2     (every member has)
//   t=11  {y, w} = 2'b10 = 2     (a rose at 10; no member has elapsed)
//   t=17  {y, w} = 2'b11 = 3     (every member has)
// A tool that ignored the delay reads y = 1 at 1 and w = 1 at 11. Four
// verdicts.
//
//! lrm A.8.3
//! lrm A.2.2.3
//! lrm A.6.5
//! lrm A.8.3:1000
//! analysis tran
//! time 0, 20n
//! checks 4
`timescale 1ns/1ns
`include "check.vh"
module annex_a_mintypmax_delay(p);
    inout p;
    electrical p;
    reg y, a;
    wire w;
    assign #(2:4:6) w = a;

    initial begin
        y = 1'b0;
        a = 1'b0;
        #(2:4:6) y = 1'b1;
    end

    initial #10 a = 1'b1;

    initial begin
        #1  `CHECKI("t=1: no member (2, 4, 6) has elapsed", y, 0);
        #6  `CHECKI("t=7: every member has, for y and w", ({y, w}), 2);
        #4  `CHECKI("t=11: a rose at 10, w has not followed", ({y, w}), 2);
        #6  `CHECKI("t=17: w followed by 16", ({y, w}), 3);
    end

    analog I(p) <+ V(p);
endmodule
