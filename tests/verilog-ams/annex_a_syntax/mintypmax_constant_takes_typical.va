// A.8.3's min:typ:max expression in the constant places Annex A writes one,
// observed by reading the values.
//
//     constant_mintypmax_expression ::= constant_expression
//             | constant_expression : constant_expression : constant_expression
//                                                                      // A.8.3
//     param_assignment ::= parameter_identifier =
//             constant_mintypmax_expression { value_range }           // A.2.4
//     defparam_assignment ::= hierarchical_parameter_identifier =
//             constant_mintypmax_expression                           // A.2.4
//     specparam_assignment ::= specparam_identifier =
//             constant_mintypmax_expression | ...                     // A.2.4
//     named_parameter_assignment ::=
//             . parameter_identifier ( [ mintypmax_expression ] )     // A.4.1
//     constant_primary ::= ... | ( constant_mintypmax_expression )   // A.8.4
//
// IEEE 1364-2005 §5.3 (inherited through §1.1): the three values "represent
// minimum, typical, and maximum values—in that order", "The three values
// allow a design to be tested with minimum, typical, or maximum delay
// values", and "The min:typ:max format can be used wherever expressions can
// appear". Its Example 1, `(a:b:c) + (d:e:f)`, has "the minimum value is the
// sum of a+d and the typical value is b+e and the maximum value is c+f".
// Which member a run takes is the tool's, so each check asserts only that
// the value is one of its expression's three.
//
// DERIVATION, every value exact in binary (min, typ, max):
//   a  = 1.0 : 2.0 : 3.0                         -> 1.0, 2.0 or 3.0
//   b  = (1.0 : 2.0 : 3.0) + (4.0 : 5.0 : 6.0)   -> 5.0, 7.0 or 9.0 (Example 1)
//   c  = 10 : 20 : 30 from [0:inf)               -> 10, 20 or 30, all inside
//   sp = 3 : 6 : 9 (a module-scope specparam)    -> 3, 6 or 9
//   scaled(2.0), whose local `k = 1.0 : 3.0 : 5.0` -> 2.0, 6.0 or 10.0
//     (A.2.8 puts parameter_declaration among an analog function's items)
//   u1: `#(.g(1.0 : 4.0 : 9.0))`                 -> g = 1.0, 4.0 or 9.0
//   u2: `defparam u2.g = 0.5 : 0.25 : 1.0;`      -> g = 0.5, 0.25 or 1.0
// Five checks in the top, one in each child: seven verdicts. A tool that
// dropped an override reads a child's declared g = 2.0, no member.
//
// MODULE ORDER IS LOAD-BEARING: the first module is the device (see
// defparam.va).
//
//! lrm A.8.3
//! lrm A.2.4
//! lrm A.4.1
//! lrm A.8.4
//! lrm A.8.3:1000
//! lrm A.2.4:1000
//! lrm A.4.1:1000
//! lrm A.8.4:1000
//! bias V(p) = 1.5
//! bias V(n) = 0.5
//! checks 7
`include "check.vh"
module annex_a_mintypmax_constant(p, n);
    inout p, n;
    electrical p, n;
    parameter real a = 1.0 : 2.0 : 3.0;
    localparam real b = (1.0 : 2.0 : 3.0) + (4.0 : 5.0 : 6.0);
    parameter integer c = 10 : 20 : 30 from [0:inf);
    specparam sp = 3 : 6 : 9;

    analog function real scaled;
        input x;
        real x;
        parameter real k = 1.0 : 3.0 : 5.0;
        scaled = k * x;
    endfunction

    annex_a_mintypmax_constant_named #(.g(1.0 : 4.0 : 9.0)) u1(p, n);
    annex_a_mintypmax_constant_defparam u2(p, n);
    defparam u2.g = 0.5 : 0.25 : 1.0;

    analog begin
        `CHECKI("parameter a = 1.0 : 2.0 : 3.0 reads one of its members", a == 1.0 || a == 2.0 || a == 3.0, 1);
        `CHECKI("(1:2:3) + (4:5:6) reads 5, 7 or 9 (IEEE 1364 5.3 Example 1)", b == 5.0 || b == 7.0 || b == 9.0, 1);
        `CHECKI("integer c = 10 : 20 : 30 from [0:inf)", c == 10 || c == 20 || c == 30, 1);
        `CHECKI("specparam sp = 3 : 6 : 9", sp == 3 || sp == 6 || sp == 9, 1);
        `CHECKI("an analog function's local parameter k = 1.0 : 3.0 : 5.0", scaled(2.0) == 2.0 || scaled(2.0) == 6.0 || scaled(2.0) == 10.0, 1);
    end
endmodule

module annex_a_mintypmax_constant_named(p, n);
    inout p, n;
    electrical p, n;
    parameter real g = 2.0;

    analog begin
        `CHECKI("#(.g(1.0 : 4.0 : 9.0)) gives g one of its members", g == 1.0 || g == 4.0 || g == 9.0, 1);
        I(p, n) <+ g * V(p, n);
    end
endmodule

module annex_a_mintypmax_constant_defparam(p, n);
    inout p, n;
    electrical p, n;
    parameter real g = 2.0;

    analog begin
        `CHECKI("defparam u2.g = 0.5 : 0.25 : 1.0 gives g one of its members", g == 0.5 || g == 0.25 || g == 1.0, 1);
        I(p, n) <+ g * V(p, n);
    end
endmodule
