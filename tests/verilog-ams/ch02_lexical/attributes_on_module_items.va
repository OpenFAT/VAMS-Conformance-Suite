// §2.9: "An attribute_instance can appear in the Verilog-AMS description as a
// prefix attached to a declaration, a module item, a statement, or a port
// connection." §2.9.1 then gives each slot. This file fills the slots no other
// chapter-2 fixture reaches, each with an attribute no tool knows
// (`conform_unknown_*`), which a tool reads or ignores as it chooses (§2.9:
// attributes are "properties ... that can be used by various tools"); the claim is only that each position
// is legal and that the item it decorates still means what it says:
//
//   Syntax 2-7 `{ attribute_instance } continuous_assign`   w = r
//   Syntax 2-7 `{ attribute_instance } initial_construct`   r = 1 at t = 0
//   Syntax 2-7 `{ attribute_instance } always_construct`    q follows r
//   Syntax 2-7 `{ attribute_instance } module_instantiation` u1 loads p
//   Syntax 2-9 port connection `( { attribute_instance } .a(p) )`
//   Syntax 2-7 `{ attribute_instance } loop_generate_construct`
//   Syntax 2-8 `function_port_list ::= { attribute_instance }
//               tf_input_declaration`                       twice(x) = 2x
//   §3.6.3.1   `(* desc="..." *) electrical d;` on a net, and the same
//              attribute on the port declaration line ("the last attribute
//              value shall be used")
//
// Values. The attributed initial clears q and t2, holds r at 0, and raises r
// at t = 0.25 (default unit 1 s). That one change is the only thing that can
// make w (the attributed assign), q and t2 (the attributed always, which
// calls twice(3) = 6) and both bits of gw (the attributed generate loop's two
// assigns) read 1, 1, 6 and 3 at the declared point t = 1; the t = 0 point
// asserts each literal against itself, since §8.4.1 leaves the DC solve and
// the first digital statements unordered. The attributed instance u1 is the
// only contribution at p, so the transcript's res[p] = V(p)/2 = 0.25 shows it
// was elaborated. No invalid form is new here; the refusals are
// attribute_illegal_placement_rejected.va and nested_attribute_rejected.va.
//
//! lrm 2.9
//! lrm 2.9.1
//! lrm 3.6.3.1
//! analysis tran
//! time 0, 1
//! bias V(p) = 0.5
`include "check.vh"
module ch02_attr_child(a);
  inout a; electrical a;
  analog I(a) <+ V(a) / 2.0;
endmodule

module ch02_attributes_on_module_items(p);
  (* desc="the probed terminal" *) inout p;
  (* desc="probed terminal" *) electrical p;
  reg r, q;
  wire w;
  wire [1:0] gw;
  integer t2;
  genvar k;
  (* conform_unknown_assign *) assign w = r;
  (* conform_unknown_initial *) initial begin q = 1'b0; t2 = 0; r = 1'b0; #0.25 r = 1'b1; end
  (* conform_unknown_always *) always @(r) begin q = r; t2 = twice(3); end
  (* conform_unknown_generate *) for (k = 0; k < 2; k = k + 1) begin : g
    assign gw[k] = r;
  end
  (* conform_unknown_instance *) ch02_attr_child u1 ((* conform_unknown_port *) .a(p));
  function integer twice((* conform_unknown_fport *) input integer x);
    twice = 2 * x;
  endfunction
  analog begin
    `CHECKI("the attributed initial, assign and always ran", ($abstime > 0.5) ? (w & q) : 1, 1);
    `CHECKI("the attributed generate loop made both assigns", ($abstime > 0.5) ? gw : 3, 3);
    `CHECKI("the function with an attributed port computes", ($abstime > 0.5) ? t2 : 6, 6);
  end
endmodule
