// §8.4.3.2: "Once the analog engine has determined its behavior for a given
// time, it must communicate the results to other processes in the mixed
// signal simulation through events and shared variables." The solution is
// accepted at "A 'wake up' event ... scheduled for the acceptance time of
// the process", an event in what §8.4.4 calls "a single event queue
// logically with a common global time". §8.5.1: "The $monitor, $strobe and
// $debug system tasks ... create monitor events for their arguments. These
// events are continuously re-enabled in every successive time step."
//
// IEEE 1364-2005 §17.1.3: "each time a variable or an expression in the
// argument list changes value—with the exception of the $time, $stime, or
// $realtime system functions—the entire argument list is displayed at the
// end of the time step".
//
// So a digital $monitor of a node potential (a probe in the discrete
// context, §7.3.3, read at the promoted digital time, §7.3.6.3) reports a
// change at the analog solution that made it, even when no digital event
// shares that time. monitor_after_macro_process.va pins the change a D2A
// event's solve makes; here nothing digital happens after time 0 at all.
//
// THE CONSTRUCTION. The analog block drives V(vo) = min(2 t / 1 ns, 4), a
// ramp that stops at 4 V. It reads no digital value, so no D2A event ever
// occurs, and the initial block's only digital event after the $monitor at
// 0 ns is at 10 ns, past the last solution, so it never runs. (The delay is
// what makes the block a digital process: a module whose discrete blocks
// never suspend is not mixed-signal, lib/ir/lower/context.zig `isMixed`.)
// The declared solutions are 0, 1, 2, 3 and 4 ns; under `timescale 1ns/1ns
// each is a digital tick, where $realtime is 0.0, 1.0, ... exactly:
//
//     t = 0 ns   first report                     V(vo) = 0
//     t = 1 ns   V(vo) moved 0 -> 2:  report       V(vo) = 2
//     t = 2 ns   V(vo) moved 2 -> 4:  report       V(vo) = 4
//     t = 3 ns   V(vo) still 4:       no report
//     t = 4 ns   V(vo) still 4:       no report
//
// Three reports, the count pinned by `//! checks`. Each prints ok = whether
// its value is one of the three above. A tool that re-checked the monitor
// only at digital time steps would print the 0 ns report alone (six checks,
// not eight). At 3 ns and 4 ns only $realtime moves, a direct argument
// 17.1.3 excepts, so neither reports. The ok expression reads no clock
// function, so it changes only when V(vo) does.
//
// Exactness: $abstime * 2.0e9 is fl(k e-9) * 2e9, exactly 2k for k = 0..4
// (python3; 2e9 is exact in binary), and the solve of a potential source
// reproduces it, so 0.0, 2.0 and 4.0 compare exactly.
//
// The analog CHECKX pins the five solutions the monitor reads, V(vo) = 0, 2,
// 4, 4, 4 at 0..4 ns, from the ramp by hand. Five analog checks and three
// reports: eight.
//
//! lrm 8.4.3.2
//! lrm 8.4.3.2:1
//! lrm 8.4.4
//! lrm 8.5.1
//! lrm 8.5.1:5
//! lrm 8.4
//! lrm 7.3.3
//! lrm 7.3.3:1000
//! lrm 7.3.6.3
//! lrm 7.3.6.3:1
//! inherited IEEE 1364-2005 17.1.3
//! analysis tran
//! time 0, 1n, 2n, 3n, 4n
//! solve
//! checks 8
`timescale 1ns/1ns
`include "check.vh"
module monitor_at_analog_only_solutions(vo);
  inout vo; electrical vo;
  initial begin
    $monitor("monitor t=%0t v=%g ok=%0d", $realtime, V(vo),
             V(vo) == `VERA_PW(0.0) || V(vo) == `VERA_PW(2.0) || V(vo) == `VERA_PW(4.0));
    #10 $monitoroff;
  end
  analog begin
    V(vo) <+ min($abstime * 2.0e9, 4.0);
    `CHECKX("the solution the monitor reads", V(vo),
            ($abstime < 0.5n) ? 0.0 : (($abstime < 1.5n) ? 2.0 : 4.0));
  end
endmodule
