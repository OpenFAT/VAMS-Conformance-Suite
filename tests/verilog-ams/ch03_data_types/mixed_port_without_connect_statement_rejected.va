// §3.11: "Signal Domain Rule: It shall be an error to connect two ports or nets
// of different domains unless there is a connect statement (see 7.4) defined
// between the disciplines of the nets or ports."
//
// `ddiscrete d` (domain discrete) is connected to ports u1.p and u2.p, declared
// `electrical` (domain continuous). The file declares a connect MODULE but no
// connect STATEMENT: there is no `connectrules` block, so nothing is "defined
// between the disciplines", and the two connections are errors. This file is
// mixed_port_with_connect_statement.va without its `connectrules`
// block; nothing else differs.
//
// VerA refuses each connection with E0927 (a mixed port matches no connect
// statement), naming the port, its discipline and the net's.
//
//! lrm 3.11
//! lrm 3.11:3
//! reject-only E0927
//! neighbour mixed_port_with_connect_statement.va
`include "check.vh"
connectmodule b1_d2a(cm, el);
  input cm;
  output el;
  ddiscrete cm;
  electrical el;
  parameter real rout = 1000.0 from (0.0:inf);
  parameter real vsup = 2.0;
  analog I(el) <+ (V(el) - vsup * ((cm == 1'b1) ? 1.0 : 0.0)) / rout;
endmodule

module b1_aload(p);
  input p;
  electrical p;
  parameter real rl = 1000.0 from (0.0:inf);
  analog I(p) <+ V(p) / rl;
endmodule

module b1_domain_top;
  ddiscrete d;
  assign d = 1'b1;
  b1_aload                 u1(d);
  b1_aload #(.rl(3000.0))  u2(d);
  analog begin
    `CHECK("u1's port sits on the bridged node", V(u1.p), 0.85714285714285710, 1e-12);
    `CHECK("u2's port sits on the same node", V(u2.p), 0.85714285714285710, 1e-12);
  end
endmodule
