// §7.8.4 insertion rule 4: "All other ports shall have an instance of the
// selected connect module, i.e., one connect module instance per port", and
// §7.8.5.1 gives a built-in primitive's terminals port names "for the
// purpose of naming the connect modules". IEEE 1364-2005 A.3.1 makes a
// primitive's instance name optional (`[ name_of_gate_instance ]`); an
// unnamed primitive still has ports, so each of its mixed ones gets a
// bridge. Neither standard spells an unnamed primitive's InstName (§7.8.5's
// `SigName__InstName__PortName`), so this file reaches only the named one
// by defparam and leaves the unnamed ones at their defaults.
//
// THE DESIGN. Three unnamed primitives and one named one, under the
// `default_discipline ddiscrete (§3.9), each with its output on an
// electrical net, a mixed OUTPUT port the d2a bridges (§7.6 Example 1):
//
//     and (a, x, x1)        unnamed: defaults vh = 1.0, vl = 0.25
//     and g1 (b, x, x1)     -> b__g1__out (§7.8.5 split, §7.8.5.1 `out`)
//     and (c, x, x0)        unnamed: defaults
//     pulldown (d)          unnamed: defaults
//
// The bridge drives V(el) <+ vh at 1, vl at 0 and 0.5 at x or z (§7.3.2's
// `===`); the defparam sets b's vh.
//
// DERIVATION. x = x1 = 1 and x0 = 0 (IEEE 1364-2005 §7.2 Table 7-1):
//     a = 1 & 1 = 1  -> V(a) = vh = 1.0
//     b = 1 & 1 = 1  -> V(b) = vh of b__g1__out = 0.6
//     c = 1 & 0 = 0  -> V(c) = vl = 0.25
//     d = 0 (pulldown, IEEE 1364-2005 §7.8) -> V(d) = vl = 0.25
// A tool that inserted no bridge on an unnamed primitive does not read vh
// or vl there. Checked at 10n and 20n: 4 checks x 2 points.
//
//! lrm 7.8.5
//! lrm 7.8.5.1
//! lrm 7.8.4
//! lrm 3.9
//! solve
//! analysis tran
//! time 10n, 20n
//! checks 8
`timescale 1ns/1ns
`include "check.vh"

connectmodule b5_pun_d2a(cm, el);
  input cm;
  output el;
  ddiscrete cm;
  electrical el;
  parameter real vh = 1.0;
  parameter real vl = 0.25;
  analog V(el) <+ (cm === 1'b1) ? vh : (cm === 1'b0) ? vl : 0.5;
endmodule

`default_discipline ddiscrete
module b5_prim_connect_unnamed;
  electrical a, b, c, d;
  reg x, x1, x0;

  and (a, x, x1);
  and g1 (b, x, x1);
  and (c, x, x0);
  pulldown (d);

  defparam b__g1__out.vh = 0.6;

  initial begin x = 1'b1; x1 = 1'b1; x0 = 1'b0; end

  analog begin
    `CHECK("the first unnamed and drives a through a bridge", V(a), 1.0, 1e-12);
    `CHECK("a named and is reached as b__g1__out", V(b), 0.6, 1e-12);
    `CHECK("the second unnamed and drives c through a bridge", V(c), 0.25, 1e-12);
    `CHECK("the unnamed pulldown drives d through a bridge", V(d), 0.25, 1e-12);
  end
endmodule
`default_discipline

connectrules b5_pun_rules;
  connect b5_pun_d2a split;
endconnectrules
