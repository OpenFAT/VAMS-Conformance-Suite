// §7.8.1 Figure 7-6, Case 2 ("If NetB is declared as cmos1 and the remaining
// interconnect is undeclared"), detail resolution (§7.4.4.2), merged. The
// figure lists "d2a at top.mix.blk2, d2a at top.digital_blk.(blk1-blk2), and
// d2a at top.digital_blk.twoblks (three connect modules)", the same line as
// Case 1's. §7.8.4's merge rule applied to Case 2 gives two (derivation
// below). The figure and the rule disagree, so this file asserts only what
// both allow: two or three connect modules, not split's four or one.
//
// The design is auto_insertion_figure_7_6_detail_merged.va's (Case 1) with
// one change: twoblks declares its port, NetB, `cmos1`. Every digital module
// (blk1..blk4 and mix's blk2, here one module `blk`) has one output port of
// discipline cmos1, `ablk`'s port is electrical, and NetD (top's `netd`),
// NetA (digital_blk's `out`) and NetC (mix's `out`) are undeclared.
//
// Each connect module loads its electrical side with 1 kohm and ablk drives
// the node with 1 mA, so the node reads V = 1e-3 * 1000 / N for N instances.
//
// DERIVATION of the rule's count, from §7.8.1, §7.8.4 and Annex F.2.2:
//  Steps 2-3. NetB is cmos1 by its in-context declaration; the leaf ports are
//    cmos1 (blk) and electrical (ablk).
//  Step 4 (depth-first, nets "not yet assigned a discipline"): NetB is
//    skipped. NetA's children are blk1, blk2 (cmos1) and NetB (cmos1): all
//    digital, so NetA is digital, cmos1. NetC's children are cmos1 and
//    electrical: "If any of the connections are analog, the net shall be
//    considered analog", electrical. NetD's children are NetA (digital) and
//    NetC (analog): electrical.
//  Step 5 (top-down, nets with no discipline "or which has been assigned a
//    digital domain from step 4"): NetA was made digital by step 4 and its
//    parent NetD is analog, so "Any others shall be considered analog":
//    NetA is electrical. NetB is not revisited: step 2 gave it its
//    discipline, not step 4.
//  Mixed ports (§7.8.4: "one of the connections to the port is digital and
//    the other is analog"): blk1, blk2 and twoblks on NetA (upper electrical,
//    lower cmos1), and mix's blk2 on NetC. Four, which is the figure's own
//    split count for Case 2 ("four connect modules").
//  Insertion: "The connect module for a port shall be instantiated in the
//    context of the ports upper connection" and "All ports connecting to the
//    same signal (upper connection), sharing the same connect module, and
//    having merged parameter shall share a single instance". blk1's, blk2's
//    and twoblks' ports all have the upper connection NetA and the module
//    cmos_d2a, merged (the default, §7.8.3): one instance in digital_blk.
//    mix's blk2 has its own on NetC. N = 2, V = 0.5.
//  The figure's third instance, "d2a at top.digital_blk.twoblks", is Case 1's
//    bridge inside twoblks on NetB; in Case 2 both connections of blk3's and
//    blk4's ports are cmos1, so no port there is mixed, and twoblks' own port
//    shares NetA's instance. The figure's reading, three, reads V = 1/3;
//    split would read 4 (V = 0.25).
//
//! lrm 7.4.4.2
//! lrm 7.4.4.2:1000
//! lrm 7.8.1
//! lrm 7.8.4
//! lrm 7.8.4:5
//! lrm 7.8.4:6
//! lrm F.2.2
//! lrm F.2.2:8
//! lrm F.2.2:14
//! discipline-resolution detail
//! solve
//! checks 1
`include "check.vh"
discipline cmos1; domain discrete; enddiscipline
connectmodule f76c2m_d2a(d, a);
  input d; cmos1 d;
  output a; electrical a;
  analog I(a) <+ V(a) / 1000.0;
endmodule
connectrules f76c2m_rules;
  connect f76c2m_d2a input cmos1, output electrical;
endconnectrules
module f76c2m_blk(out); output out; cmos1 out; endmodule
module f76c2m_ablk(out);
  output out; electrical out;
  analog begin
    I(out) <+ -1.0e-3;
    `CHECK("2 (rule) or 3 (figure) connect modules load the node: V = 1/2 or 1/3", min(abs(V(out) - 0.5), abs(V(out) - 1.0 / 3.0)), 0.0, 1e-12);
  end
endmodule
module f76c2m_twoblks(out);
  output out;
  cmos1 out;
  f76c2m_blk b3(out);
  f76c2m_blk b4(out);
endmodule
module f76c2m_digital_blk(out);
  output out;
  f76c2m_blk b1(out);
  f76c2m_blk b2(out);
  f76c2m_twoblks t(out);
endmodule
module f76c2m_mix(out);
  output out;
  f76c2m_blk b2(out);
  f76c2m_ablk a(out);
endmodule
module f76c2m_top;
  f76c2m_digital_blk d(netd);
  f76c2m_mix m(netd);
endmodule
