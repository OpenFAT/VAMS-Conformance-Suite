// §7.2.4, second paragraph: "If an undeclared net segment has multiple
// compatible disciplines connected to it, a connect statement SHALL specify
// which discipline to use during discipline resolution."
//
// §7.4.1 is the same rule from the resolution side: "if multiple compatible
// disciplines are connected to the same net via multiple ports ONLY ONE
// discipline can be assigned to that net. This is controlled by the resolveto
// form of the connect statement".
//
// The paragraph before it sets the scene the fixture builds: "A mixed signal can
// have a number of compatible continuous nets, with different continuous
// disciplines and different abstols." Here `sig` is undeclared and reaches:
//
//   - `lo` through a port of discipline ch724_loose (abstol 10u),
//   - `hi` through a port of discipline ch724_tight (abstol 100n), compatible
//     with the first (both potential natures derive from ch724_v, §3.11.1),
//   - `dg` through a port of a discrete discipline (ch724_dd) — so `sig` is a MIXED signal,
//     the clause's subject.
//
// The connectrules block holds only connect INSERTION statements (§7.7.1), one
// bridge per continuous discipline, so §3.11's Signal Domain Rule ("it shall be
// an error to connect two ports or nets of different domains unless there is a
// connect statement") is satisfied and cannot be the diagnostic. There is no
// RESOLUTION statement (§7.7.2, `resolveto`), which is what the clause requires,
// so the discipline of `sig` is not specified — annex F.2.1 step 4.b's fourth
// bullet names the consequence for a net with a mixed-port connection: "this
// is an error" (E0903).
//
// The positive half is `figure_7_2_resolveto_two_levels.va`, where the same
// kind of set is resolved by a `resolveto` statement and the result read back.
// `annex_f_resolution/unknown_discipline_mixed_port.va` is the annex's own
// fixture of the error, over natureless disciplines; this one is §7.2.4's
// shape, with the different abstols that make the choice observable.
//
//! lrm 7.2.4
//! lrm 7.2.4:2
//! lrm 7.4.1
//! lrm F.2.1
//! lrm F.2.1:7
//! reject-only E0903
//! reject E0922
//! neighbour figure_7_2_resolveto_two_levels.va
//
// No `include "disciplines.vams"`: ch724_i and ch724_v are base natures with
// access I and V, and §3.13.2 says "the access function of each base nature
// shall be unique", so with D.1 included they would collide with annex D's
// Current and Voltage. ch724_dd stands in for annex D's ddiscrete for the
// same reason.
discipline ch724_dd; domain discrete; enddiscipline
nature ch724_i;
  units = "A";
  access = I;
  abstol = 1p;
endnature
nature ch724_v;
  units = "V";
  access = V;
  abstol = 1u;
endnature
nature ch724_v_loose : ch724_v;
  abstol = 10u;
endnature
nature ch724_v_tight : ch724_v;
  abstol = 100n;
endnature
discipline ch724_loose; domain continuous; potential ch724_v_loose; flow ch724_i; enddiscipline
discipline ch724_tight; domain continuous; potential ch724_v_tight; flow ch724_i; enddiscipline

connectmodule ch724_loose_bridge(c, d);
  inout c; inout d;
  ch724_loose c;
  ch724_dd d;
endmodule
connectmodule ch724_tight_bridge(c, d);
  inout c; inout d;
  ch724_tight c;
  ch724_dd d;
endmodule
connectrules ch724_crossings;
  connect ch724_loose_bridge;
  connect ch724_tight_bridge;
endconnectrules

module ch724_loose_leaf(p);
  inout p; ch724_loose p;
  analog I(p) <+ V(p) / 1k;
endmodule
module ch724_tight_leaf(p);
  inout p; ch724_tight p;
  analog I(p) <+ V(p) / 2k;
endmodule
module ch724_dig_leaf(d);
  inout d; ch724_dd d;
endmodule

module ch724_top;
  ch724_loose_leaf lo(sig);
  ch724_tight_leaf hi(sig);
  ch724_dig_leaf   dg(sig);
endmodule
