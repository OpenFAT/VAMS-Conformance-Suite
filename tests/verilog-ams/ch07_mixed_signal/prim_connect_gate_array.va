// IEEE 1364-2005 §7.1.5/§7.1.6: an array of gate instances `and g[1:0] (...)`
// is one gate per index, a terminal as wide as the array giving each gate
// one bit (the leftmost index the most significant) and a scalar terminal
// being every gate's. VAMS §7.8.4: "All other ports shall have an instance of
// the selected connect module, i.e., one connect module instance per port",
// and §7.8.5 names a split one SigName__InstName__PortName. Each element of
// the array is an instance with ports of its own (§7.8.5.1's names), so each
// gets its own bridge. Neither standard spells an array element's InstName,
// so this file reaches no bridge by name and counts them by their load.
//
// THE DESIGN. `and g[1:0] (y, a, b)`: y is a 2-bit wire (one bit per gate),
// a is the scalar electrical node (every gate's in1), b a 2-bit reg (one bit
// per gate). Under `default_discipline ddiscrete (§3.9) each element's in1
// is a mixed INPUT port the a2d bridges (§7.6 Example 2), split: two
// bridges, one per element.
//
// DERIVATION. Each a2d loads `a` with I(el) <+ V(el)/rin, rin = 1 kohm.
// With the module's own 1 kohm shunt and 1 mA into `a`:
//     V/1000 + V/1000 + V/1000 = 1e-3  =>  V(a) = 1/3
// One bridge for the whole array reads 1/2; none reads 1.
// Each a2d drives its discrete side to 1 at time zero. b = 2'b10, so g[1]
// (bit 1, the leftmost) gives y[1] = 1 & 1 = 1 and g[0] gives y[0] = 1 & 0 =
// 0 (IEEE 1364-2005 §7.2 Table 7-1): y = 2, copied into yr. A gate array
// left reading the analog node sees neither 0 nor 1 there: y[1] = x.
// Checked at 10n and 20n: 2 checks x 2 points.
//
//! lrm 7.8.4
//! lrm 7.8.4:7
//! lrm 7.8.5
//! lrm 7.8.5.1
//! lrm 3.9
//! inherited IEEE 1364-2005 7.1.5
//! inherited IEEE 1364-2005 7.1.6
//! solve
//! analysis tran
//! time 10n, 20n
//! checks 4
`timescale 1ns/1ns
`include "check.vh"

connectmodule b5_pga_a2d(el, cm);
  input el;
  output cm;
  electrical el;
  ddiscrete cm;
  reg cm;
  parameter real rin = 1000.0 from (0.0:inf);
  analog I(el) <+ V(el) / rin;
  initial cm = 1'b1;
endmodule

`default_discipline ddiscrete
module b5_prim_connect_gate_array;
  electrical a;
  wire [1:0] y;
  reg [1:0] b, yr;

  and g[1:0] (y, a, b);

  always @(y) yr = y;
  initial b = 2'b10;

  analog begin
    I(a) <+ V(a) / 1000.0;
    I(a) <+ -1.0e-3;
    `CHECK("one a2d per element: V = 1/3", V(a), 1.0 / 3.0, 1e-12);
    `CHECKI("each element reads its own bridge: y = {1 & b[1], 1 & b[0]} = 2", yr, 2);
  end
endmodule
`default_discipline

connectrules b5_pga_rules;
  connect b5_pga_a2d split;
endconnectrules
