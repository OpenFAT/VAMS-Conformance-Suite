// §7.3.1 Table 7-1, the `bit` row: "Discrete bit and bit groupings (buses
// and part selects) are accessed in the continuous context as integer
// numbers. ... The lowest bit of the bit grouping is mapped to the zeroth
// bit of the integer. ... Access of discrete bit groupings with greater than
// 31 bits is illegal." The limit is on the grouping's width, not on where it
// sits in the `reg`: a 31-bit (or narrower) select above bit 31 of a wide
// `reg` is as legal as one below it.
//
// IEEE 1364-2005 §4.2.1: the right-hand bound of the declared range is the
// LSB in either direction, so q[0:47]'s bit 47 is bit 0 of its value.
//
// THE DESIGN. Not a mixed module (its one `initial` block assigns constants
// and never waits), so both registers hold their initial literal for the
// whole analysis: 48'h1234_5678_9abc. Nothing analog assigns them.
//
// DERIVATION. Bits 47..32 are the top four hex digits, 0x1234 = 4660.
//   r[47:32]  0x1234                                        = 4660
//   r[41]     bit 9 of 0x1234: 0x1234 >> 9 = 0x9, odd       = 1
//   r[40:20]  the 21 bits from bit 20: 0x1234_5678_9abc >> 20 drops five
//             hex digits, 0x1234567; & 0x1fffff (21 bits) = 0x034567
//                                                           = 214375
//   q[0:15]   q[0] is bit 47 and q[15] is bit 32: the same as r[47:32]
//                                                           = 4660
// One check each, at the one operating point: checks 4. A tool that held
// the `reg` as a 32-bit integer reads 0 for the first three (or refuses
// them); one that counted q from its left bound reads bits 15..0 (0x9abc).
//
// See also discrete_bus_part_select_analog_assigned_rejected.va: the analog
// context may read these selects, not assign them (§5.7, §7.3).
//
//! lrm 7.3.1
//! inherited IEEE 1364-2005 4.2.1
//! checks 4
`include "check.vh"
module ch7_discrete_bus_part_select_above_31_lit(p);
  inout p; electrical p;
  reg [47:0] r;
  reg [0:47] q;
  initial begin
    r = 48'h1234_5678_9abc;
    q = 48'h1234_5678_9abc;
  end
  analog begin
    `CHECKI("r[47:32] lies wholly above bit 31", r[47:32], 4660);
    `CHECKI("r[41]", r[41], 1);
    `CHECKI("r[40:20] spans bit 31", r[40:20], 214375);
    `CHECKI("q[0:15] of an ascending range: q[47] is the LSB", q[0:15], 4660);
    I(p) <+ V(p);
  end
endmodule
