// AMS §7.3.1 Table 7-1: "If the bus width is less than 31 bits, the higher
// bits of the integer are set to zero (0)." The analog read is a 32-bit
// integer, not a narrow expression. §9.14 imports IEEE §17.11.1's unsigned
// interpretation. Only a digital process writes a reg (§7.3; §5.7 refuses
// one on an analog left-hand side), so a digital initial block assigns the
// regs and the analog block reads them. -1 leaves four bits 1111: the read is 15,
// $clog2 is 4, and its 32-bit complement is 2**32-16, whose ceiling log is
// 32. A local integer -1 stays 32 bits; leaving its scope restores the reg.
// One bit of -1 is 1 -> 0; 31 bits are 2**31-1 -> 31. Scalarized and runtime
// indexed reg array elements undergo the same read conversion, so each is
// 15 -> 4; the other runtime element holds 1 -> 0, so a read that ignores the
// index (0 at this bias) fails. The illegal width neighbour is
// reject_clog2_reg_width.va.
//! lrm 7.3.1
//! lrm 9.14
//! bias V(p) = 0, V(n) = 0
//! checks 9
`include "check.vh"
module clog2_reg_analog_conversion(p, n);
  inout p, n; electrical p, n;
  parameter integer WIDTH = 4;
  reg [WIDTH-1:0] value;
  reg single;
  reg [30:0] largest;
  reg [3:0] fixed_element[0:0];
  reg [3:0] dynamic_element[0:1];
  integer index;
  initial begin
    value = -1;
    single = -1;
    largest = -1;
    fixed_element[0] = -1;
    dynamic_element[0] = -1;
    dynamic_element[1] = 1;
  end
  analog begin
    `CHECKI("packed read is zero extended", value, 15);
    `CHECKI("packed reg clog2", $clog2(value), 4);
    `CHECKI("reg complement uses analog integer width", $clog2(~value), 32);
    begin : inner
      integer value;
      value = -1;
      `CHECKI("local integer shadows reg conversion", $clog2(value), 32);
    end
    `CHECKI("outer reg conversion restored", $clog2(value), 4);
    `CHECKI("scalar bit", $clog2(single), 0);
    `CHECKI("widest analog bit grouping", $clog2(largest), 31);
    `CHECKI("scalarized reg array element", $clog2(fixed_element[0]), 4);
    index = $rtoi(V(p, n));
    `CHECKI("runtime indexed reg array element", $clog2(dynamic_element[index]), 4);
    I(p, n) <+ V(p, n);
  end
endmodule
