// AMS §3.4.1 derives an inferred parameter from its final HDL override;
// §9.14 imports IEEE 1364-2005 §17.11.1's unsigned interpretation.
// The child starts with a four-bit default but its HDL override has 64 bits:
// 2**63+1 has ceiling log 64, through both direct use and a dependent default.
// A signed four-bit parameter and its inferred alias both contain 15 -> 4.
// An explicit [3:0] range fixes four bits despite an eight-bit initializer:
// ff is truncated to f, so both direct and dependent $clog2 are 4.
// The child's parameter-bound range has the same result after flattening,
// as does its packed reg whose four one bits read as analog integer 15. Its
// `initial` block sets the reg: §5.7 lets an analog assignment target only an
// integer, real or string, and §7.3 writes a variable only from its own domain.
//
// HOST CARD VALUES (specification/Vague_Decisions.md VD-089). IEEE 1364-2005 12.2: an
// untyped, unranged parameter takes "the type and range of the final override
// value assigned to the parameter"; 4.10.1:
// a parameter "with no type or range specification shall default to the type
// and range of the final value assigned to the parameter, after any value
// overrides have been applied". A card value has no Verilog width, so VerA
// reads it as an unsized integer (3.5.1: 32 bits, signed; 64 when the value
// needs them), and a declared range still fixes the width (4.10.1).
//   knob = 4'd1, card 255: 255 at 32 bits is 0...011111111, and 2**7 < 255 <=
//     2**8 -> 8, in direct use and in the dependent localparam alike. (Read
//     at the 4-bit default's width it would be 1111 -> 4.)
//   knob_ranged = [3:0], card 255: the range keeps 4 bits, 1111 -> 4.
//   knob_negative = 4'd1, card -1: 32 one bits, 2**31 < 2**32 - 1 <= 2**32
//     -> 32.
//   knob_wide = 4'd1, card 2**33 = 8589934592: no 32-bit integer holds it,
//     so 64 bits; 2**33 is a power of two -> 33.
// signed_tiny is the same kind of parameter with no card value: its final
// value is still 4'shf, 4 bits, so it stays 4 (the third analog check).
//! lrm 3.4.1
//! lrm 9.14
//! lrm 5.7
//! inherited IEEE 1364-2005 4.10.1 12.2
//! param knob = 255
//! param knob_ranged = 255
//! param knob_negative = -1
//! param knob_wide = 8589934592
//! checks 13
`include "check.vh"
module clog2_width_child;
  parameter integer BITS = 4;
  parameter code = 4'h1;
  parameter [BITS-1:0] packed_child = 8'hff;
  localparam integer derived = $clog2(code);
  reg [BITS-1:0] bits;
  initial bits = -1;
  analog begin
    `CHECKI("HDL override supplies its 64-bit width", $clog2(code), 64);
    `CHECKI("dependent default uses overridden HDL width", derived, 64);
    `CHECKI("child packed range follows its renamed parameter", $clog2(packed_child), 4);
    `CHECKI("child reg width follows its renamed parameter", $clog2(bits), 4);
  end
endmodule
module clog2_inferred_parameter_width;
  parameter knob = 4'd1;
  parameter [3:0] knob_ranged = 4'd1;
  parameter knob_negative = 4'd1;
  parameter knob_wide = 4'd1;
  parameter signed_tiny = 4'shf;
  localparam copy = signed_tiny;
  parameter [3:0] packed_tiny = 8'hff;
  localparam integer packed_derived = $clog2(packed_tiny);
  localparam integer derived = $clog2(knob);
  clog2_width_child #(.code(64'h8000000000000001)) child();
  analog begin
    `CHECKI("a card value is an unsized integer", $clog2(knob), 8);
    `CHECKI("dependent default reads the card value unsized", derived, 8);
    `CHECKI("a declared range keeps its width under a card value", $clog2(knob_ranged), 4);
    `CHECKI("a negative card value is 32 bits", $clog2(knob_negative), 32);
    `CHECKI("a card value past 32 bits is 64 bits", $clog2(knob_wide), 33);
    `CHECKI("inferred signed parameter", $clog2(signed_tiny), 4);
    `CHECKI("inferred parameter alias", $clog2(copy), 4);
    `CHECKI("explicit packed range takes precedence", $clog2(packed_tiny), 4);
    `CHECKI("dependent default keeps explicit packed range", packed_derived, 4);
  end
endmodule
