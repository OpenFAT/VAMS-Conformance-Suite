// §2.9 Syntax 2-4: `attr_spec ::= attr_name [ = constant_expression ]`, for
// every attribute, one no tool knows included.
//
// The attribute's value is `vtox`, an analog block variable, which is not a
// constant_expression (§4.1: "The operands of a constant expression consists
// of constant numbers and parameter names"). `conform_unknown` means nothing
// to any tool, so this is the §2.9 rule alone. VerA reports E0357.
//! lrm 2.9
//! lrm 2.9:2
//! reject-only E0357
//! neighbour limit_seed_mos1_initjct.va
`include "disciplines.vams"
module reject_attribute_value_not_constant(p, n);
  inout p, n; electrical p, n, a;
  parameter real vto = 0.7, vt = 0.025, vcrit = 0.6;
  real vtox, v;
  analog begin
    vtox = vto;
    (* conform_unknown = vtox *) v = $limit(V(a, n), "pnjlim", vt, vcrit);
    I(p, a) <+ V(p, a) / 10.0;
    I(a, n) <+ 1e-14 * (limexp(v / vt) - 1.0);
  end
endmodule
