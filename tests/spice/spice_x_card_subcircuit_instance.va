// E.2: "The subcircuits and models contained within the SPICE netlist are
// treated as module definitions", and E.1.1: "In general, anything that can
// be instantiated in the particular flavor of SPICE can also be
// instantiated within a Verilog-AMS HDL module." Inside a netlist, a
// subcircuit instantiates another with an X card, `Xname nodes... subckt
// [PARAMS:] k=v ...`: an instance of that module by position, each `k=v` an
// override, and `M=` E.4.1's multiplicity (§6.3.6 `$mfactor`).
//
// NODE 0. In SPICE, node 0 is the ground everywhere, inside a subcircuit
// too. The synthesized module declares it `ground` (§3.6.4: the net "will be
// the global reference node in the circuit"); as a plain name it would be a
// local net and X2 would hang from nothing.
//
// THE NETLIST.
//
//     .SUBCKT RLEG A B PARAMS: R=1K
//     R1 A B {R}
//     .ENDS RLEG
//     .SUBCKT VDIV IN OUT
//     X1 IN OUT RLEG R=1K
//     X2 OUT 0 RLEG PARAMS: R=6K M=2
//     .ENDS VDIV
//
// THE DIGITS, BY HAND. V(in) = 1. X1 is 1k from in to out; X2 is two 6k legs
// in parallel (M = 2), 3k from out to ground:
//
//     V(out) = 1 * 3k / (1k + 3k) = 0.75
//
// Wrong readings: node 0 a local net (X2 floating) gives 1.0; M ignored,
// 6/7 = 0.857; X2's R ignored (1k, M = 2), 0.5/1.5 = 0.333.
//
// No refusal neighbour: an X card has no form of its own that E.2 forbids.
// One that names no module is §6's unknown module (E0904).
// Node 0 has no invalid use.
//
//! lrm E.2
//! lrm E.1.1
//! lrm E.4.1
//! lrm 3.6.4
//! lrm 6.7.1
//! bias V(in) = 1.0
//! solve
//! spice .SUBCKT RLEG A B PARAMS: R=1K
//! spice R1 A B {R}
//! spice .ENDS RLEG
//! spice .SUBCKT VDIV IN OUT
//! spice X1 IN OUT RLEG R=1K
//! spice X2 OUT 0 RLEG PARAMS: R=6K M=2
//! spice .ENDS VDIV
//! checks 1
`include "check.vh"
module annex_e_spice_x_card(in);
  inout in; electrical in;
  vdiv x1(in, mid);
  analog begin
    `CHECK("1k over two 6k legs in parallel to SPICE's ground node 0", V(x1.out), 0.75, 1e-12);
  end
endmodule
