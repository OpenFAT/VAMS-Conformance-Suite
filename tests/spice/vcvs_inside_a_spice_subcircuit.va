// E.3.1 lists the SPICE controlled sources a subcircuit may hold, and E.2
// makes "the subcircuits and models contained within the SPICE netlist"
// module definitions. This is the voltage-controlled voltage source, the `E`
// card in its plain four-node form.
//
// THE NETLIST. A gain-of-two amplifier driving a load:
//
//     .SUBCKT AMP IN OUT GND
//     RI IN GND 1K       input load, no effect on the gain
//     E1 OUT GND IN GND 2
//     RL OUT GND 1K
//     .ENDS AMP
//
// THE DIGITS, BY HAND, with SPICE's E-element convention (V(n+, n-) =
// gain * V(nc+, nc-)). `//! bias` holds in at 1.0 V and gnd at 0.0 V:
//
//     V(out, gnd) = 2 * V(in, gnd) = 2 * 1.0 = 2.0 V
//
// The source is ideal, so RL draws current without moving V(out). A dropped
// E card leaves V(out) at 0; swapped control nodes give -2.0.
//
//! lrm E.3.1
//! lrm E.3.1:1000
//! lrm E.2
//! bias V(in) = 1.0, V(gnd) = 0.0
//! solve
//! spice .SUBCKT AMP IN OUT GND
//! spice RI IN GND 1K
//! spice E1 OUT GND IN GND 2
//! spice RL OUT GND 1K
//! spice .ENDS AMP
`include "check.vh"
module annex_e_vcvs_inside_a_spice_subcircuit(in, gnd);
  inout in, gnd; electrical in, gnd;
  amp x1(in, out, gnd);
  analog begin
    `CHECK("E.3.1 a vcvs inside a SPICE subcircuit doubles its control voltage",
           V(x1.out, x1.gnd), 2.0, 1e-9);
  end
endmodule
