// OpenVAF resolves `include "constants.va"` to VAMS-LRM annex D's header
// (openvaf/vfs/src/va_std.rs); the LRM names that header constants.vams.
`include "constants.vams"
